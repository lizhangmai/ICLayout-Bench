* Derived from analog-db ldo_001_analoggym_basic, fixed snapshot
* 263d0322f8900dc331536fbbe6c0e804514fc454. Copyright 2026 Danial Noori Zadeh.
* Required Notice: Copyright 2026 Danial Noori Zadeh
* Modified: equivalent fingering, explicit physical passives/taps;
* reference 0.225 V and added 4 pF net10-output MIM compensation.
* Normalized material: PolyForm Noncommercial 1.0.0; CODA-Team BSD component.
* See collection LICENSE and NOTICE.
.subckt ldo_001_analoggym_basic vdd vout vss ib vref vfb sense
XM12 vb4 vb3 net28 sub sg13_lv_nmos w=7.5u l=1.5u m=8
XM13 dm_1 vb3 net31 sub sg13_lv_nmos w=7.5u l=1.5u m=8
XM14 vb3 vb3 vss sub sg13_lv_nmos w=7.5u l=1.5u m=2
XM15 voutn vb3 dm_2 sub sg13_lv_nmos w=7.5u l=1.5u m=8
XM16 net10 vb3 net106 sub sg13_lv_nmos w=7.5u l=1.5u m=8
XM17 net28 vb4 vss sub sg13_lv_nmos w=7.5u l=1.5u m=8
XM18 net31 vb4 vss sub sg13_lv_nmos w=7.5u l=1.5u m=8
XM19 dm_2 vb4 vss sub sg13_lv_nmos w=7.5u l=1.5u m=16
XM20 net106 vb4 vss sub sg13_lv_nmos w=7.5u l=1.5u m=16
XM21 net12 net7 vss sub sg13_lv_nmos w=6u l=2u m=120
XM22 net7 net7 vss sub sg13_lv_nmos w=6u l=2u m=120
XM10 net12 net10 net1 well_net1 sg13_lv_pmos w=8u l=0.5u m=12
XRtap_net1_0 net1 well_net1 ntap1 A=4e-12 P=8e-6
XRtap_net1_1 net1 well_net1 ntap1 A=4e-12 P=8e-6
XRtap_net1_2 net1 well_net1 ntap1 A=4e-12 P=8e-6
XRtap_net1_3 net1 well_net1 ntap1 A=4e-12 P=8e-6
XM8 dm_2 sense net20 well_net20 sg13_lv_pmos w=10u l=1u m=3
XM9 net106 vref net20 well_net20 sg13_lv_pmos w=10u l=1u m=3
XRtap_net20_0 net20 well_net20 ntap1 A=4e-12 P=8e-6
XRtap_net20_1 net20 well_net20 ntap1 A=4e-12 P=8e-6
XRtap_net20_2 net20 well_net20 ntap1 A=4e-12 P=8e-6
XM0 ib ib vdd well_vdd sg13_lv_pmos w=5u l=2u m=3
XM1 vb4 ib vdd well_vdd sg13_lv_pmos w=5u l=2u m=3
XM11 vout net1 vdd well_vdd sg13_lv_pmos w=9u l=0.15u m=464
XM2 dm_1 ib vdd well_vdd sg13_lv_pmos w=5u l=2u m=3
XM24 net1 ib vdd well_vdd sg13_lv_pmos w=5u l=2u m=3
XM3 vb3 ib vdd well_vdd sg13_lv_pmos w=5u l=2u m=3
XM4 net20 ib vdd well_vdd sg13_lv_pmos w=10u l=2u m=3
XM5 voutn voutn vdd well_vdd sg13_lv_pmos w=5u l=2u m=3
XM6 net10 voutn vdd well_vdd sg13_lv_pmos w=5u l=2u m=3
XM7 net7 ib vdd well_vdd sg13_lv_pmos w=5u l=2u m=3
XRtap_vdd_0 vdd well_vdd ntap1 A=4e-12 P=8e-6
XRtap_vdd_1 vdd well_vdd ntap1 A=4e-12 P=8e-6
XRtap_vdd_2 vdd well_vdd ntap1 A=4e-12 P=8e-6
XRtap_vdd_3 vdd well_vdd ntap1 A=4e-12 P=8e-6
XRtap_vdd_4 vdd well_vdd ntap1 A=4e-12 P=8e-6
XRtap_vdd_5 vdd well_vdd ntap1 A=4e-12 P=8e-6
XRtap_vdd_6 vdd well_vdd ntap1 A=4e-12 P=8e-6
XRtap_vdd_7 vdd well_vdd ntap1 A=4e-12 P=8e-6
XRtap_vdd_8 vdd well_vdd ntap1 A=4e-12 P=8e-6
XRtap_vdd_9 vdd well_vdd ntap1 A=4e-12 P=8e-6
XRtap_vdd_10 vdd well_vdd ntap1 A=4e-12 P=8e-6
XRtap_vdd_11 vdd well_vdd ntap1 A=4e-12 P=8e-6
XRtap_vdd_12 vdd well_vdd ntap1 A=4e-12 P=8e-6
XRtap_vdd_13 vdd well_vdd ntap1 A=4e-12 P=8e-6
XRtap_vdd_14 vdd well_vdd ntap1 A=4e-12 P=8e-6
XRtap_vdd_15 vdd well_vdd ntap1 A=4e-12 P=8e-6
XRtap_vdd_16 vdd well_vdd ntap1 A=4e-12 P=8e-6
XRtap_vdd_17 vdd well_vdd ntap1 A=4e-12 P=8e-6
XRtap_vdd_18 vdd well_vdd ntap1 A=4e-12 P=8e-6
XRtap_vdd_19 vdd well_vdd ntap1 A=4e-12 P=8e-6
XRtap_vdd_20 vdd well_vdd ntap1 A=4e-12 P=8e-6
XRtap_vdd_21 vdd well_vdd ntap1 A=4e-12 P=8e-6
XRtap_vdd_22 vdd well_vdd ntap1 A=4e-12 P=8e-6
XRtap_vdd_23 vdd well_vdd ntap1 A=4e-12 P=8e-6
XRtap_vdd_24 vdd well_vdd ntap1 A=4e-12 P=8e-6
XRtap_vdd_25 vdd well_vdd ntap1 A=4e-12 P=8e-6
XRtap_vdd_26 vdd well_vdd ntap1 A=4e-12 P=8e-6
XRtap_vdd_27 vdd well_vdd ntap1 A=4e-12 P=8e-6
XRtap_vdd_28 vdd well_vdd ntap1 A=4e-12 P=8e-6
XRtap_vdd_29 vdd well_vdd ntap1 A=4e-12 P=8e-6
XRtap_vdd_30 vdd well_vdd ntap1 A=4e-12 P=8e-6
XRtap_vdd_31 vdd well_vdd ntap1 A=4e-12 P=8e-6
XRtap_vdd_32 vdd well_vdd ntap1 A=4e-12 P=8e-6
XRtap_vdd_33 vdd well_vdd ntap1 A=4e-12 P=8e-6
XRtap_vdd_34 vdd well_vdd ntap1 A=4e-12 P=8e-6
XRtap_vdd_35 vdd well_vdd ntap1 A=4e-12 P=8e-6
XRtap_vdd_36 vdd well_vdd ntap1 A=4e-12 P=8e-6
XRtap_vdd_37 vdd well_vdd ntap1 A=4e-12 P=8e-6
XRtap_vdd_38 vdd well_vdd ntap1 A=4e-12 P=8e-6
XRtap_vdd_39 vdd well_vdd ntap1 A=4e-12 P=8e-6
XRtap_vdd_40 vdd well_vdd ntap1 A=4e-12 P=8e-6
XRtap_vdd_41 vdd well_vdd ntap1 A=4e-12 P=8e-6
XRtap_vdd_42 vdd well_vdd ntap1 A=4e-12 P=8e-6
XRtap_vdd_43 vdd well_vdd ntap1 A=4e-12 P=8e-6
XRtap_vdd_44 vdd well_vdd ntap1 A=4e-12 P=8e-6
XRtap_vdd_45 vdd well_vdd ntap1 A=4e-12 P=8e-6
XRtap_vdd_46 vdd well_vdd ntap1 A=4e-12 P=8e-6
XRtap_vdd_47 vdd well_vdd ntap1 A=4e-12 P=8e-6
XRtap_vdd_48 vdd well_vdd ntap1 A=4e-12 P=8e-6
XRtap_vdd_49 vdd well_vdd ntap1 A=4e-12 P=8e-6
XRtap_vdd_50 vdd well_vdd ntap1 A=4e-12 P=8e-6
XRtap_vdd_51 vdd well_vdd ntap1 A=4e-12 P=8e-6
XRtap_vdd_52 vdd well_vdd ntap1 A=4e-12 P=8e-6
XRtap_vdd_53 vdd well_vdd ntap1 A=4e-12 P=8e-6
XRtap_vdd_54 vdd well_vdd ntap1 A=4e-12 P=8e-6
XRtap_vdd_55 vdd well_vdd ntap1 A=4e-12 P=8e-6
XRtap_vdd_56 vdd well_vdd ntap1 A=4e-12 P=8e-6
XRtap_vdd_57 vdd well_vdd ntap1 A=4e-12 P=8e-6
XRtap_vdd_58 vdd well_vdd ntap1 A=4e-12 P=8e-6
XRtap_vdd_59 vdd well_vdd ntap1 A=4e-12 P=8e-6
XRtap_vdd_60 vdd well_vdd ntap1 A=4e-12 P=8e-6
XRtap_vdd_61 vdd well_vdd ntap1 A=4e-12 P=8e-6
XRtap_vdd_62 vdd well_vdd ntap1 A=4e-12 P=8e-6
XRtap_vdd_63 vdd well_vdd ntap1 A=4e-12 P=8e-6
XRtap_vdd_64 vdd well_vdd ntap1 A=4e-12 P=8e-6
XRtap_vdd_65 vdd well_vdd ntap1 A=4e-12 P=8e-6
XRtap_vdd_66 vdd well_vdd ntap1 A=4e-12 P=8e-6
XRtap_vdd_67 vdd well_vdd ntap1 A=4e-12 P=8e-6
XRtap_vdd_68 vdd well_vdd ntap1 A=4e-12 P=8e-6
XRtap_vdd_69 vdd well_vdd ntap1 A=4e-12 P=8e-6
XRtap_vdd_70 vdd well_vdd ntap1 A=4e-12 P=8e-6
XRtap_vdd_71 vdd well_vdd ntap1 A=4e-12 P=8e-6
XRtap_vdd_72 vdd well_vdd ntap1 A=4e-12 P=8e-6
XRtap_vdd_73 vdd well_vdd ntap1 A=4e-12 P=8e-6
XRtap_vdd_74 vdd well_vdd ntap1 A=4e-12 P=8e-6
XRtap_vdd_75 vdd well_vdd ntap1 A=4e-12 P=8e-6
XRtap_vdd_76 vdd well_vdd ntap1 A=4e-12 P=8e-6
XRtap_vdd_77 vdd well_vdd ntap1 A=4e-12 P=8e-6
XRtap_vdd_78 vdd well_vdd ntap1 A=4e-12 P=8e-6
XRtap_vdd_79 vdd well_vdd ntap1 A=4e-12 P=8e-6
XRtap_vdd_80 vdd well_vdd ntap1 A=4e-12 P=8e-6
XRtap_vdd_81 vdd well_vdd ntap1 A=4e-12 P=8e-6
XRtap_vdd_82 vdd well_vdd ntap1 A=4e-12 P=8e-6
XRtap_vdd_83 vdd well_vdd ntap1 A=4e-12 P=8e-6
XRtap_vdd_84 vdd well_vdd ntap1 A=4e-12 P=8e-6
XRtap_vdd_85 vdd well_vdd ntap1 A=4e-12 P=8e-6
XRtap_vdd_86 vdd well_vdd ntap1 A=4e-12 P=8e-6
XRtap_vdd_87 vdd well_vdd ntap1 A=4e-12 P=8e-6
XRtap_vdd_88 vdd well_vdd ntap1 A=4e-12 P=8e-6
XRtap_vdd_89 vdd well_vdd ntap1 A=4e-12 P=8e-6
XRtap_vdd_90 vdd well_vdd ntap1 A=4e-12 P=8e-6
XRtap_vdd_91 vdd well_vdd ntap1 A=4e-12 P=8e-6
XRtap_vdd_92 vdd well_vdd ntap1 A=4e-12 P=8e-6
XRtap_vdd_93 vdd well_vdd ntap1 A=4e-12 P=8e-6
XRtap_vdd_94 vdd well_vdd ntap1 A=4e-12 P=8e-6
XRtap_vdd_95 vdd well_vdd ntap1 A=4e-12 P=8e-6
XRtap_vdd_96 vdd well_vdd ntap1 A=4e-12 P=8e-6
XRtap_vdd_97 vdd well_vdd ntap1 A=4e-12 P=8e-6
XRtap_vdd_98 vdd well_vdd ntap1 A=4e-12 P=8e-6
XRtap_vdd_99 vdd well_vdd ntap1 A=4e-12 P=8e-6
XRtap_vdd_100 vdd well_vdd ntap1 A=4e-12 P=8e-6
XRtap_vdd_101 vdd well_vdd ntap1 A=4e-12 P=8e-6
XRtap_vdd_102 vdd well_vdd ntap1 A=4e-12 P=8e-6
XRtap_vdd_103 vdd well_vdd ntap1 A=4e-12 P=8e-6
XRtap_vdd_104 vdd well_vdd ntap1 A=4e-12 P=8e-6
XRtap_vdd_105 vdd well_vdd ntap1 A=4e-12 P=8e-6
XRtap_vdd_106 vdd well_vdd ntap1 A=4e-12 P=8e-6
XRtap_vdd_107 vdd well_vdd ntap1 A=4e-12 P=8e-6
XRtap_vdd_108 vdd well_vdd ntap1 A=4e-12 P=8e-6
XRtap_vdd_109 vdd well_vdd ntap1 A=4e-12 P=8e-6
XRtap_vdd_110 vdd well_vdd ntap1 A=4e-12 P=8e-6
XRtap_vdd_111 vdd well_vdd ntap1 A=4e-12 P=8e-6
XRtap_vdd_112 vdd well_vdd ntap1 A=4e-12 P=8e-6
XRtap_vdd_113 vdd well_vdd ntap1 A=4e-12 P=8e-6
XRtap_vdd_114 vdd well_vdd ntap1 A=4e-12 P=8e-6
XRtap_vdd_115 vdd well_vdd ntap1 A=4e-12 P=8e-6
XRtap_vdd_116 vdd well_vdd ntap1 A=4e-12 P=8e-6
XRtap_vdd_117 vdd well_vdd ntap1 A=4e-12 P=8e-6
XRtap_vdd_118 vdd well_vdd ntap1 A=4e-12 P=8e-6
XRtap_vdd_119 vdd well_vdd ntap1 A=4e-12 P=8e-6
XRtap_vdd_120 vdd well_vdd ntap1 A=4e-12 P=8e-6
XRtap_vdd_121 vdd well_vdd ntap1 A=4e-12 P=8e-6
XRtap_vdd_122 vdd well_vdd ntap1 A=4e-12 P=8e-6
XRtap_vdd_123 vdd well_vdd ntap1 A=4e-12 P=8e-6
XRtap_vdd_124 vdd well_vdd ntap1 A=4e-12 P=8e-6
XRtap_vdd_125 vdd well_vdd ntap1 A=4e-12 P=8e-6
XRtap_vdd_126 vdd well_vdd ntap1 A=4e-12 P=8e-6
XRtap_vdd_127 vdd well_vdd ntap1 A=4e-12 P=8e-6
XRtap_vdd_128 vdd well_vdd ntap1 A=4e-12 P=8e-6
XRtap_vdd_129 vdd well_vdd ntap1 A=4e-12 P=8e-6
XRtap_vdd_130 vdd well_vdd ntap1 A=4e-12 P=8e-6
XRptap_0 vss sub ptap1 A=4e-12 P=8e-6
XRptap_1 vss sub ptap1 A=4e-12 P=8e-6
XRptap_2 vss sub ptap1 A=4e-12 P=8e-6
XRptap_3 vss sub ptap1 A=4e-12 P=8e-6
XRptap_4 vss sub ptap1 A=4e-12 P=8e-6
XRptap_5 vss sub ptap1 A=4e-12 P=8e-6
XRptap_6 vss sub ptap1 A=4e-12 P=8e-6
XRptap_7 vss sub ptap1 A=4e-12 P=8e-6
XRptap_8 vss sub ptap1 A=4e-12 P=8e-6
XRptap_9 vss sub ptap1 A=4e-12 P=8e-6
XRptap_10 vss sub ptap1 A=4e-12 P=8e-6
XRptap_11 vss sub ptap1 A=4e-12 P=8e-6
XRptap_12 vss sub ptap1 A=4e-12 P=8e-6
XRptap_13 vss sub ptap1 A=4e-12 P=8e-6
XRptap_14 vss sub ptap1 A=4e-12 P=8e-6
XRptap_15 vss sub ptap1 A=4e-12 P=8e-6
XRptap_16 vss sub ptap1 A=4e-12 P=8e-6
XRptap_17 vss sub ptap1 A=4e-12 P=8e-6
XRptap_18 vss sub ptap1 A=4e-12 P=8e-6
XRptap_19 vss sub ptap1 A=4e-12 P=8e-6
XRptap_20 vss sub ptap1 A=4e-12 P=8e-6
XRptap_21 vss sub ptap1 A=4e-12 P=8e-6
XRptap_22 vss sub ptap1 A=4e-12 P=8e-6
XRptap_23 vss sub ptap1 A=4e-12 P=8e-6
XRptap_24 vss sub ptap1 A=4e-12 P=8e-6
XRptap_25 vss sub ptap1 A=4e-12 P=8e-6
XRptap_26 vss sub ptap1 A=4e-12 P=8e-6
XRptap_27 vss sub ptap1 A=4e-12 P=8e-6
XRptap_28 vss sub ptap1 A=4e-12 P=8e-6
XRptap_29 vss sub ptap1 A=4e-12 P=8e-6
XRptap_30 vss sub ptap1 A=4e-12 P=8e-6
XRptap_31 vss sub ptap1 A=4e-12 P=8e-6
XRptap_32 vss sub ptap1 A=4e-12 P=8e-6
XRptap_33 vss sub ptap1 A=4e-12 P=8e-6
XRptap_34 vss sub ptap1 A=4e-12 P=8e-6
XRptap_35 vss sub ptap1 A=4e-12 P=8e-6
XRptap_36 vss sub ptap1 A=4e-12 P=8e-6
XRptap_37 vss sub ptap1 A=4e-12 P=8e-6
XRptap_38 vss sub ptap1 A=4e-12 P=8e-6
XRptap_39 vss sub ptap1 A=4e-12 P=8e-6
XRptap_40 vss sub ptap1 A=4e-12 P=8e-6
XRptap_41 vss sub ptap1 A=4e-12 P=8e-6
XRptap_42 vss sub ptap1 A=4e-12 P=8e-6
XRptap_43 vss sub ptap1 A=4e-12 P=8e-6
XRptap_44 vss sub ptap1 A=4e-12 P=8e-6
XRptap_45 vss sub ptap1 A=4e-12 P=8e-6
XRptap_46 vss sub ptap1 A=4e-12 P=8e-6
XRptap_47 vss sub ptap1 A=4e-12 P=8e-6
XRptap_48 vss sub ptap1 A=4e-12 P=8e-6
XRptap_49 vss sub ptap1 A=4e-12 P=8e-6
XRptap_50 vss sub ptap1 A=4e-12 P=8e-6
XRptap_51 vss sub ptap1 A=4e-12 P=8e-6
XRptap_52 vss sub ptap1 A=4e-12 P=8e-6
XRptap_53 vss sub ptap1 A=4e-12 P=8e-6
XRptap_54 vss sub ptap1 A=4e-12 P=8e-6
XRptap_55 vss sub ptap1 A=4e-12 P=8e-6
XRptap_56 vss sub ptap1 A=4e-12 P=8e-6
XRptap_57 vss sub ptap1 A=4e-12 P=8e-6
XRptap_58 vss sub ptap1 A=4e-12 P=8e-6
XRptap_59 vss sub ptap1 A=4e-12 P=8e-6
XRptap_60 vss sub ptap1 A=4e-12 P=8e-6
XRptap_61 vss sub ptap1 A=4e-12 P=8e-6
XRptap_62 vss sub ptap1 A=4e-12 P=8e-6
XRptap_63 vss sub ptap1 A=4e-12 P=8e-6
XRptap_64 vss sub ptap1 A=4e-12 P=8e-6
XRptap_65 vss sub ptap1 A=4e-12 P=8e-6
XRptap_66 vss sub ptap1 A=4e-12 P=8e-6
XRptap_67 vss sub ptap1 A=4e-12 P=8e-6
XRptap_68 vss sub ptap1 A=4e-12 P=8e-6
XRptap_69 vss sub ptap1 A=4e-12 P=8e-6
XRptap_70 vss sub ptap1 A=4e-12 P=8e-6
XRptap_71 vss sub ptap1 A=4e-12 P=8e-6
XRptap_72 vss sub ptap1 A=4e-12 P=8e-6
XRptap_73 vss sub ptap1 A=4e-12 P=8e-6
XRptap_74 vss sub ptap1 A=4e-12 P=8e-6
XRptap_75 vss sub ptap1 A=4e-12 P=8e-6
XRptap_76 vss sub ptap1 A=4e-12 P=8e-6
XRptap_77 vss sub ptap1 A=4e-12 P=8e-6
XRptap_78 vss sub ptap1 A=4e-12 P=8e-6
XRptap_79 vss sub ptap1 A=4e-12 P=8e-6
XRptap_80 vss sub ptap1 A=4e-12 P=8e-6
XRptap_81 vss sub ptap1 A=4e-12 P=8e-6
XRptap_82 vss sub ptap1 A=4e-12 P=8e-6
XRptap_83 vss sub ptap1 A=4e-12 P=8e-6
XRptap_84 vss sub ptap1 A=4e-12 P=8e-6
XRptap_85 vss sub ptap1 A=4e-12 P=8e-6
XRptap_86 vss sub ptap1 A=4e-12 P=8e-6
XRptap_87 vss sub ptap1 A=4e-12 P=8e-6
XRptap_88 vss sub ptap1 A=4e-12 P=8e-6
XRptap_89 vss sub ptap1 A=4e-12 P=8e-6
XRptap_90 vss sub ptap1 A=4e-12 P=8e-6
XRptap_91 vss sub ptap1 A=4e-12 P=8e-6
XRptap_92 vss sub ptap1 A=4e-12 P=8e-6
XRptap_93 vss sub ptap1 A=4e-12 P=8e-6
XRptap_94 vss sub ptap1 A=4e-12 P=8e-6
XRptap_95 vss sub ptap1 A=4e-12 P=8e-6
XRptap_96 vss sub ptap1 A=4e-12 P=8e-6
XRptap_97 vss sub ptap1 A=4e-12 P=8e-6
XRptap_98 vss sub ptap1 A=4e-12 P=8e-6
XRptap_99 vss sub ptap1 A=4e-12 P=8e-6
XRptap_100 vss sub ptap1 A=4e-12 P=8e-6
XRptap_101 vss sub ptap1 A=4e-12 P=8e-6
XRptap_102 vss sub ptap1 A=4e-12 P=8e-6
XRptap_103 vss sub ptap1 A=4e-12 P=8e-6
XRptap_104 vss sub ptap1 A=4e-12 P=8e-6
XRptap_105 vss sub ptap1 A=4e-12 P=8e-6
XRptap_106 vss sub ptap1 A=4e-12 P=8e-6
XRptap_107 vss sub ptap1 A=4e-12 P=8e-6
XRptap_108 vss sub ptap1 A=4e-12 P=8e-6
XRptap_109 vss sub ptap1 A=4e-12 P=8e-6
XRptap_110 vss sub ptap1 A=4e-12 P=8e-6
XRptap_111 vss sub ptap1 A=4e-12 P=8e-6
XRptap_112 vss sub ptap1 A=4e-12 P=8e-6
XRptap_113 vss sub ptap1 A=4e-12 P=8e-6
XRptap_114 vss sub ptap1 A=4e-12 P=8e-6
XRptap_115 vss sub ptap1 A=4e-12 P=8e-6
XRptap_116 vss sub ptap1 A=4e-12 P=8e-6
XRptap_117 vss sub ptap1 A=4e-12 P=8e-6
XRptap_118 vss sub ptap1 A=4e-12 P=8e-6
XRptap_119 vss sub ptap1 A=4e-12 P=8e-6
XRptap_120 vss sub ptap1 A=4e-12 P=8e-6
XRptap_121 vss sub ptap1 A=4e-12 P=8e-6
XRptap_122 vss sub ptap1 A=4e-12 P=8e-6
XRptap_123 vss sub ptap1 A=4e-12 P=8e-6
XRptap_124 vss sub ptap1 A=4e-12 P=8e-6
XRptap_125 vss sub ptap1 A=4e-12 P=8e-6
XRptap_126 vss sub ptap1 A=4e-12 P=8e-6
XRptap_127 vss sub ptap1 A=4e-12 P=8e-6
XRptap_128 vss sub ptap1 A=4e-12 P=8e-6
XRptap_129 vss sub ptap1 A=4e-12 P=8e-6
XRptap_130 vss sub ptap1 A=4e-12 P=8e-6
XRptap_131 vss sub ptap1 A=4e-12 P=8e-6
XRptap_132 vss sub ptap1 A=4e-12 P=8e-6
XRptap_133 vss sub ptap1 A=4e-12 P=8e-6
XRptap_134 vss sub ptap1 A=4e-12 P=8e-6
XRptap_135 vss sub ptap1 A=4e-12 P=8e-6
XRptap_136 vss sub ptap1 A=4e-12 P=8e-6
XRptap_137 vss sub ptap1 A=4e-12 P=8e-6
XRptap_138 vss sub ptap1 A=4e-12 P=8e-6
XRptap_139 vss sub ptap1 A=4e-12 P=8e-6
XRptap_140 vss sub ptap1 A=4e-12 P=8e-6
XRptap_141 vss sub ptap1 A=4e-12 P=8e-6
XRptap_142 vss sub ptap1 A=4e-12 P=8e-6
XRptap_143 vss sub ptap1 A=4e-12 P=8e-6
XRptap_144 vss sub ptap1 A=4e-12 P=8e-6
XRptap_145 vss sub ptap1 A=4e-12 P=8e-6
XRptap_146 vss sub ptap1 A=4e-12 P=8e-6
XRptap_147 vss sub ptap1 A=4e-12 P=8e-6
XRptap_148 vss sub ptap1 A=4e-12 P=8e-6
XRptap_149 vss sub ptap1 A=4e-12 P=8e-6
XRptap_150 vss sub ptap1 A=4e-12 P=8e-6
XRptap_151 vss sub ptap1 A=4e-12 P=8e-6
XRptap_152 vss sub ptap1 A=4e-12 P=8e-6
XRptap_153 vss sub ptap1 A=4e-12 P=8e-6
XRptap_154 vss sub ptap1 A=4e-12 P=8e-6
XRptap_155 vss sub ptap1 A=4e-12 P=8e-6
XRptap_156 vss sub ptap1 A=4e-12 P=8e-6
XRptap_157 vss sub ptap1 A=4e-12 P=8e-6
XRptap_158 vss sub ptap1 A=4e-12 P=8e-6
XRptap_159 vss sub ptap1 A=4e-12 P=8e-6
XRptap_160 vss sub ptap1 A=4e-12 P=8e-6
XRptap_161 vss sub ptap1 A=4e-12 P=8e-6
XRptap_162 vss sub ptap1 A=4e-12 P=8e-6
XRptap_163 vss sub ptap1 A=4e-12 P=8e-6
XRptap_164 vss sub ptap1 A=4e-12 P=8e-6
XRptap_165 vss sub ptap1 A=4e-12 P=8e-6
XRptap_166 vss sub ptap1 A=4e-12 P=8e-6
XRptap_167 vss sub ptap1 A=4e-12 P=8e-6
XRptap_168 vss sub ptap1 A=4e-12 P=8e-6
XRptap_169 vss sub ptap1 A=4e-12 P=8e-6
XRptap_170 vss sub ptap1 A=4e-12 P=8e-6
XRptap_171 vss sub ptap1 A=4e-12 P=8e-6
XRptap_172 vss sub ptap1 A=4e-12 P=8e-6
XRptap_173 vss sub ptap1 A=4e-12 P=8e-6
XRptap_174 vss sub ptap1 A=4e-12 P=8e-6
XRptap_175 vss sub ptap1 A=4e-12 P=8e-6
XRptap_176 vss sub ptap1 A=4e-12 P=8e-6
XRptap_177 vss sub ptap1 A=4e-12 P=8e-6
XRptap_178 vss sub ptap1 A=4e-12 P=8e-6
XRptap_179 vss sub ptap1 A=4e-12 P=8e-6
XRptap_180 vss sub ptap1 A=4e-12 P=8e-6
XRptap_181 vss sub ptap1 A=4e-12 P=8e-6
XRptap_182 vss sub ptap1 A=4e-12 P=8e-6
XRptap_183 vss sub ptap1 A=4e-12 P=8e-6
XRptap_184 vss sub ptap1 A=4e-12 P=8e-6
XRptap_185 vss sub ptap1 A=4e-12 P=8e-6
XRptap_186 vss sub ptap1 A=4e-12 P=8e-6
XRptap_187 vss sub ptap1 A=4e-12 P=8e-6
XRptap_188 vss sub ptap1 A=4e-12 P=8e-6
XRptap_189 vss sub ptap1 A=4e-12 P=8e-6
XRptap_190 vss sub ptap1 A=4e-12 P=8e-6
XRptap_191 vss sub ptap1 A=4e-12 P=8e-6
XRptap_192 vss sub ptap1 A=4e-12 P=8e-6
XRptap_193 vss sub ptap1 A=4e-12 P=8e-6
XRptap_194 vss sub ptap1 A=4e-12 P=8e-6
XRptap_195 vss sub ptap1 A=4e-12 P=8e-6
XRptap_196 vss sub ptap1 A=4e-12 P=8e-6
XRptap_197 vss sub ptap1 A=4e-12 P=8e-6
XRptap_198 vss sub ptap1 A=4e-12 P=8e-6
XRptap_199 vss sub ptap1 A=4e-12 P=8e-6
XRptap_200 vss sub ptap1 A=4e-12 P=8e-6
XRptap_201 vss sub ptap1 A=4e-12 P=8e-6
XRptap_202 vss sub ptap1 A=4e-12 P=8e-6
XRptap_203 vss sub ptap1 A=4e-12 P=8e-6
XRptap_204 vss sub ptap1 A=4e-12 P=8e-6
XRptap_205 vss sub ptap1 A=4e-12 P=8e-6
XRptap_206 vss sub ptap1 A=4e-12 P=8e-6
XRptap_207 vss sub ptap1 A=4e-12 P=8e-6
XRptap_208 vss sub ptap1 A=4e-12 P=8e-6
XRptap_209 vss sub ptap1 A=4e-12 P=8e-6
XRptap_210 vss sub ptap1 A=4e-12 P=8e-6
XRptap_211 vss sub ptap1 A=4e-12 P=8e-6
XRptap_212 vss sub ptap1 A=4e-12 P=8e-6
XRptap_213 vss sub ptap1 A=4e-12 P=8e-6
XRptap_214 vss sub ptap1 A=4e-12 P=8e-6
XRptap_215 vss sub ptap1 A=4e-12 P=8e-6
XRptap_216 vss sub ptap1 A=4e-12 P=8e-6
XRptap_217 vss sub ptap1 A=4e-12 P=8e-6
XRptap_218 vss sub ptap1 A=4e-12 P=8e-6
XRptap_219 vss sub ptap1 A=4e-12 P=8e-6
XRptap_220 vss sub ptap1 A=4e-12 P=8e-6
XRptap_221 vss sub ptap1 A=4e-12 P=8e-6
XRptap_222 vss sub ptap1 A=4e-12 P=8e-6
XRptap_223 vss sub ptap1 A=4e-12 P=8e-6
XRptap_224 vss sub ptap1 A=4e-12 P=8e-6
XRptap_225 vss sub ptap1 A=4e-12 P=8e-6
XRptap_226 vss sub ptap1 A=4e-12 P=8e-6
XRptap_227 vss sub ptap1 A=4e-12 P=8e-6
XRptap_228 vss sub ptap1 A=4e-12 P=8e-6
XRptap_229 vss sub ptap1 A=4e-12 P=8e-6
XRptap_230 vss sub ptap1 A=4e-12 P=8e-6
XRptap_231 vss sub ptap1 A=4e-12 P=8e-6
XRptap_232 vss sub ptap1 A=4e-12 P=8e-6
XRptap_233 vss sub ptap1 A=4e-12 P=8e-6
XRptap_234 vss sub ptap1 A=4e-12 P=8e-6
XRptap_235 vss sub ptap1 A=4e-12 P=8e-6
XRptap_236 vss sub ptap1 A=4e-12 P=8e-6
XRptap_237 vss sub ptap1 A=4e-12 P=8e-6
XRptap_238 vss sub ptap1 A=4e-12 P=8e-6
XRptap_239 vss sub ptap1 A=4e-12 P=8e-6
XRptap_240 vss sub ptap1 A=4e-12 P=8e-6
XRptap_241 vss sub ptap1 A=4e-12 P=8e-6
XRptap_242 vss sub ptap1 A=4e-12 P=8e-6
XRptap_243 vss sub ptap1 A=4e-12 P=8e-6
XRptap_244 vss sub ptap1 A=4e-12 P=8e-6
XRptap_245 vss sub ptap1 A=4e-12 P=8e-6
XRptap_246 vss sub ptap1 A=4e-12 P=8e-6
XRptap_247 vss sub ptap1 A=4e-12 P=8e-6
XRptap_248 vss sub ptap1 A=4e-12 P=8e-6
XRptap_249 vss sub ptap1 A=4e-12 P=8e-6
XRptap_250 vss sub ptap1 A=4e-12 P=8e-6
XC0_0 net106 vout cap_cmim w=42.685u l=42.685u m=1
XC0_1 net106 vout cap_cmim w=42.685u l=42.685u m=1
XC0_2 net106 vout cap_cmim w=42.685u l=42.685u m=1
XCLOCAL_0 net10 vout cap_cmim w=51.64u l=51.64u m=1
XR1_0 vout r11 sub rhigh w=1u l=17.465u m=1 b=0
XR1_1 r11 r12 sub rhigh w=1u l=17.465u m=1 b=0
XR1_2 r12 r13 sub rhigh w=1u l=17.465u m=1 b=0
XR1_3 r13 r14 sub rhigh w=1u l=17.465u m=1 b=0
XR1_4 r14 r15 sub rhigh w=1u l=17.465u m=1 b=0
XR1_5 r15 r16 sub rhigh w=1u l=17.465u m=1 b=0
XR1_6 r16 r17 sub rhigh w=1u l=17.465u m=1 b=0
XR1_7 r17 r18 sub rhigh w=1u l=17.465u m=1 b=0
XR1_8 r18 r19 sub rhigh w=1u l=17.465u m=1 b=0
XR1_9 r19 r110 sub rhigh w=1u l=17.465u m=1 b=0
XR1_10 r110 r111 sub rhigh w=1u l=17.465u m=1 b=0
XR1_11 r111 vfb sub rhigh w=1u l=17.465u m=1 b=0
XR2_0 vfb r21 sub rhigh w=1u l=17.465u m=1 b=0
XR2_1 r21 r22 sub rhigh w=1u l=17.465u m=1 b=0
XR2_2 r22 r23 sub rhigh w=1u l=17.465u m=1 b=0
XR2_3 r23 vss sub rhigh w=1u l=17.465u m=1 b=0
.ends ldo_001_analoggym_basic
