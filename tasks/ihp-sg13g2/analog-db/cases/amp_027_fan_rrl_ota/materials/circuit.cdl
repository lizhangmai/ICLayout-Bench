* Copyright 2026 Danial Noori Zadeh. See collection LICENSE and NOTICE.
* Fixed IHP binding; external bias ports and native physical taps.
.subckt amp_027_fan_rrl_ota vinp vinn voutp voutn vdd vss vb1 vb2 vb3 vb4
RT0 vdd well_0 ntap1 A=4e-12 P=8e-6
MM1 tail vb3 vdd well_0 sg13_lv_pmos w=20u l=1u m=1
RT1 vdd well_1 ntap1 A=4e-12 P=8e-6
MM10 voutp vb1 d1p well_1 sg13_lv_pmos w=10u l=0.3u m=1
RT2 vss sub ptap1 A=4e-12 P=8e-6
MM11 voutn vb2 csrc_n sub sg13_lv_nmos w=5u l=0.3u m=1
RT3 vss sub ptap1 A=4e-12 P=8e-6
MM12 voutp vb2 csrc_p sub sg13_lv_nmos w=5u l=0.3u m=1
RT4 vss sub ptap1 A=4e-12 P=8e-6
MM13 csrc_n cm_bias vss sub sg13_lv_nmos w=6u l=1u m=1
RT5 vss sub ptap1 A=4e-12 P=8e-6
MM14 csrc_p cm_bias vss sub sg13_lv_nmos w=6u l=1u m=1
RT6 vss sub ptap1 A=4e-12 P=8e-6
MM15 cm_bias cm_bias vss sub sg13_lv_nmos w=2u l=1u m=1
RT7 vss sub ptap1 A=4e-12 P=8e-6
MM16 cm_sense cm_sense vss sub sg13_lv_nmos w=2u l=1u m=1
RT8 vdd well_8 ntap1 A=4e-12 P=8e-6
MM2 d1n vinp tail well_8 sg13_lv_pmos w=20u l=0.5u m=1
RT9 vdd well_9 ntap1 A=4e-12 P=8e-6
MM3 d1p vinn tail well_9 sg13_lv_pmos w=20u l=0.5u m=1
RT10 vdd well_10 ntap1 A=4e-12 P=8e-6
MM4 cm_tail vb3 vdd well_10 sg13_lv_pmos w=10u l=1u m=1
RT11 vdd well_11 ntap1 A=4e-12 P=8e-6
MM5 cm_sense voutn cm_tail well_11 sg13_lv_pmos w=4u l=0.5u m=1
RT12 vdd well_12 ntap1 A=4e-12 P=8e-6
MM6 cm_bias vb4 cm_tail well_12 sg13_lv_pmos w=4u l=0.5u m=1
RT13 vdd well_13 ntap1 A=4e-12 P=8e-6
MM7 cm_sense voutp cm_tail well_13 sg13_lv_pmos w=4u l=0.5u m=1
RT14 vdd well_14 ntap1 A=4e-12 P=8e-6
MM8 cm_bias vb4 cm_tail well_14 sg13_lv_pmos w=4u l=0.5u m=1
RT15 vdd well_15 ntap1 A=4e-12 P=8e-6
MM9 voutn vb1 d1n well_15 sg13_lv_pmos w=10u l=0.3u m=1
RTSUB vss sub ptap1 A=4e-12 P=8e-6
.ends amp_027_fan_rrl_ota
