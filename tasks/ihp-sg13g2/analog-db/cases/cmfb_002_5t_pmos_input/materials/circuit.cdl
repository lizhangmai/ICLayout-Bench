* Copyright 2026 Danial Noori Zadeh. See collection LICENSE and NOTICE.
* Fixed IHP binding; external bias ports and native physical taps.
.subckt cmfb_002_5t_pmos_input vinp vinn vcmfb vref vdd vss
RT0 vdd well_0 ntap1 A=4e-12 P=8e-6
MM1 ptail bias vdd well_0 sg13_lv_pmos w=0.33u l=0.27u m=1
RT1 vss sub ptap1 A=4e-12 P=8e-6
MM2 vcmfb mirr vss sub sg13_lv_nmos w=2.32u l=1.31u m=1
RT2 vdd well_2 ntap1 A=4e-12 P=8e-6
MM3 bias bias vdd well_2 sg13_lv_pmos w=0.88u l=0.26u m=1
RT3 vdd well_3 ntap1 A=4e-12 P=8e-6
MM4 mirr cm_sense ptail well_3 sg13_lv_pmos w=1.42u l=0.27u m=1
RT4 vdd well_4 ntap1 A=4e-12 P=8e-6
MM5 vcmfb vref ptail well_4 sg13_lv_pmos w=1.42u l=0.27u m=1
RT5 vss sub ptap1 A=4e-12 P=8e-6
MM6 mirr mirr vss sub sg13_lv_nmos w=2.32u l=1.31u m=1
RT6 vss sub ptap1 A=4e-12 P=8e-6
MM7 bias bias vss sub sg13_lv_nmos w=0.29u l=0.22u m=1
RTSUB vss sub ptap1 A=4e-12 P=8e-6
RRMN_0 vinn RMN_s1 sub rhigh w=.5u l=84.45u m=1 b=0
RRMN_1 RMN_s1 RMN_s2 sub rhigh w=.5u l=84.45u m=1 b=0
RRMN_2 RMN_s2 RMN_s3 sub rhigh w=.5u l=84.45u m=1 b=0
RRMN_3 RMN_s3 cm_sense sub rhigh w=.5u l=84.45u m=1 b=0
RRMP_0 cm_sense RMP_s1 sub rhigh w=.5u l=84.45u m=1 b=0
RRMP_1 RMP_s1 RMP_s2 sub rhigh w=.5u l=84.45u m=1 b=0
RRMP_2 RMP_s2 RMP_s3 sub rhigh w=.5u l=84.45u m=1 b=0
RRMP_3 RMP_s3 vinp sub rhigh w=.5u l=84.45u m=1 b=0
.ends cmfb_002_5t_pmos_input
