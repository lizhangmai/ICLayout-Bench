* Layout-Bench independent characterization. SPDX-License-Identifier: MIT
.lib /workspace/support/models/cornerMOSlv.lib mos_tt
.lib /workspace/support/models/cornerRES.lib res_typ
.lib /workspace/support/models/cornerCAP.lib cap_typ
.include dut.spice
.include parameters.spice
.temp 27
.option rshunt=1e12 method=gear maxord=2
VDD vdd 0 1.5
VP vinp 0 PWL(0 {0.75+diff_v} 40u {0.75+diff_v} 40.1u {common_v+diff_v} 100u {common_v+diff_v})
VN vinn 0 PWL(0 {0.75-diff_v} 40u {0.75-diff_v} 40.1u {common_v-diff_v} 100u {common_v-diff_v})
VR vcm 0 .75
VB vbias 0 .6
VPH phi 0 PULSE(1.5 0 1u 2n 2n 5u 10u)
VPL phin 0 PULSE(0 1.5 1u 2n 2n 5u 10u)
CL out 0 1p
XD vinp vinn out vcm vbias phi phin vdd 0 cmfb_004_output_switched_cap
.save v(out) v(vinp) v(vinn) v(phi) v(phin) i(vph) i(vpl)
.control
set noaskquit
set numdgt=12
tran 1n 100u
let output=v(out)
meas tran output_v find output at=95u
let err=abs(output-(0.6+v(vinp)*0.5+v(vinn)*0.5-0.75))
meas tran sample_error_v max err from=92u to=95u
let held=abs(output-output_v)
meas tran hold_drift_v max held from=96.1u to=99u
let cp=(abs(-v(phi)*i(vph))-v(phi)*i(vph)+abs(-v(phin)*i(vpl))-v(phin)*i(vpl))/2
meas tran clock_power_w avg cp from=80u to=100u
write transient.raw all
quit
.endc
.end
