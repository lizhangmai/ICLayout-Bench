* Derived from analog-db amp_007_leung_dfcfc2, fixed snapshot
* 263d0322f8900dc331536fbbe6c0e804514fc454. Copyright 2026 Danial Noori Zadeh.
* See collection LICENSE and NOTICE. Modified: process-grid dimensions, physical passives, explicit bias and separate body taps.
.subckt amp_007_leung_dfcfc2 vss vdd vinn vinp vout net1
MM13 vb4 vb3 net54 sub sg13_lv_nmos w=1u l=1u m=16
MM14 dm_1 vb3 net56 sub sg13_lv_nmos w=1u l=1u m=16
MM15 vb3 vb3 vss sub sg13_lv_nmos w=1u l=1u m=4
MM16 voutn vb3 dm_2 sub sg13_lv_nmos w=1u l=1u m=16
MM17 net050 vb3 net063 sub sg13_lv_nmos w=1u l=1u m=16
MM18 net54 vb4 vss sub sg13_lv_nmos w=1u l=1u m=16
MM19 net56 vb4 vss sub sg13_lv_nmos w=1u l=1u m=16
MM20 dm_2 vb4 vss sub sg13_lv_nmos w=1u l=1u m=32
MM21 net063 vb4 vss sub sg13_lv_nmos w=1u l=1u m=32
MM22 net2 vb4 vss sub sg13_lv_nmos w=1u l=1u m=16
MM23 net043 net043 vss sub sg13_lv_nmos w=1u l=1u m=4
MM24 net049 net043 vss sub sg13_lv_nmos w=1u l=1u m=4
MM25 vout net049 vss sub sg13_lv_nmos w=1u l=1u m=4
MM8 dm_2 vinn net31 well_net31 sg13_lv_pmos w=1u l=1u m=100
MM9 net063 vinp net31 well_net31 sg13_lv_pmos w=1u l=1u m=100
RRtap_net31 net31 well_net31 ntap1 A=2412e-12 P=2416e-6
MM0 net1 net1 vdd well_vdd sg13_lv_pmos w=1u l=1u m=4
MM1 vb4 net1 vdd well_vdd sg13_lv_pmos w=1u l=1u m=4
MM10 net2 net050 vdd well_vdd sg13_lv_pmos w=1u l=1u m=4
MM11 net043 net050 vdd well_vdd sg13_lv_pmos w=1u l=1u m=4
MM12 vout net050 vdd well_vdd sg13_lv_pmos w=1u l=1u m=4
MM2 dm_1 net1 vdd well_vdd sg13_lv_pmos w=1u l=1u m=4
MM3 vb3 net1 vdd well_vdd sg13_lv_pmos w=1u l=1u m=4
MM4 net31 net1 vdd well_vdd sg13_lv_pmos w=1u l=1u m=8
MM5 voutn voutn vdd well_vdd sg13_lv_pmos w=1u l=1u m=4
MM6 net050 voutn vdd well_vdd sg13_lv_pmos w=1u l=1u m=4
MM7 net049 net1 vdd well_vdd sg13_lv_pmos w=1u l=1u m=4
RRtap_vdd vdd well_vdd ntap1 A=642e-12 P=646e-6
RRptap vss sub ptap1 A=5508e-12 P=5512e-6
CC1_0 net050 vout cap_cmim w=47.61u l=47.61u m=1
CC1_1 net050 vout cap_cmim w=47.61u l=47.61u m=1
CC1_2 net050 vout cap_cmim w=47.61u l=47.61u m=1
CC1_3 net050 vout cap_cmim w=47.61u l=47.61u m=1
CC1_4 net050 vout cap_cmim w=47.61u l=47.61u m=1
CC2_0 net050 net2 cap_cmim w=47.61u l=47.61u m=1
CC2_1 net050 net2 cap_cmim w=47.61u l=47.61u m=1
CC2_2 net050 net2 cap_cmim w=47.61u l=47.61u m=1
CC2_3 net050 net2 cap_cmim w=47.61u l=47.61u m=1
CC2_4 net050 net2 cap_cmim w=47.61u l=47.61u m=1
.ends amp_007_leung_dfcfc2
