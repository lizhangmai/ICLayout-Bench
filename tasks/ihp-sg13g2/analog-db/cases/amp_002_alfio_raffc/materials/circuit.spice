* Derived from analog-db amp_002_alfio_raffc, fixed snapshot
* 263d0322f8900dc331536fbbe6c0e804514fc454. Copyright 2026 Danial Noori Zadeh.
* See collection LICENSE and NOTICE. Modified: process-grid dimensions, physical passives, explicit bias and separate body taps.
.subckt amp_002_alfio_raffc vss vdd vinn vinp vout net1
XM12 vb4 vb3 net54 sub sg13_lv_nmos w=2u l=8u m=4
XM13 dm_1 vb3 net56 sub sg13_lv_nmos w=2u l=8u m=4
XM14 vb3 vb3 vss sub sg13_lv_nmos w=2u l=8u m=1
XM15 voutn vb3 dm_2 sub sg13_lv_nmos w=8u l=1u m=2
XM16 net050 vb3 net063 sub sg13_lv_nmos w=8u l=1u m=2
XM17 net54 vb4 vss sub sg13_lv_nmos w=2u l=8u m=4
XM18 net56 vb4 vss sub sg13_lv_nmos w=2u l=8u m=4
XM19 dm_2 vb4 vss sub sg13_lv_nmos w=2u l=8u m=8
XM20 net063 vb4 vss sub sg13_lv_nmos w=2u l=8u m=8
XM21 net043 net043 vss sub sg13_lv_nmos w=9u l=2u m=6
XM22 vout net043 vss sub sg13_lv_nmos w=9u l=2u m=6
XM59 net013 vb4 vss sub sg13_lv_nmos w=2u l=8u m=8
XM8 dm_2 vinn net31 well_net31 sg13_lv_pmos w=10u l=3.15u m=3
XM9 net063 vinp net31 well_net31 sg13_lv_pmos w=10u l=3.15u m=3
XRtap_net31 net31 well_net31 ntap1 A=109.8e-12 P=113.8e-6
XM0 net1 net1 vdd well_vdd sg13_lv_pmos w=5.74u l=6.12u m=1
XM1 vb4 net1 vdd well_vdd sg13_lv_pmos w=5.74u l=6.12u m=1
XM10 net013 net050 vdd well_vdd sg13_lv_pmos w=7.2u l=1u m=1
XM11 vout net050 vdd well_vdd sg13_lv_pmos w=10u l=0.8u m=2
XM2 dm_1 net1 vdd well_vdd sg13_lv_pmos w=5.74u l=6.12u m=1
XM3 vb3 net1 vdd well_vdd sg13_lv_pmos w=5.74u l=6.12u m=1
XM4 net31 net1 vdd well_vdd sg13_lv_pmos w=5.74u l=6.12u m=2
XM5 voutn voutn vdd well_vdd sg13_lv_pmos w=5.74u l=6.12u m=8
XM6 net050 voutn vdd well_vdd sg13_lv_pmos w=5.74u l=6.12u m=8
XM7 net043 net013 vdd well_vdd sg13_lv_pmos w=6.24u l=0.4u m=1
XRtap_vdd vdd well_vdd ntap1 A=595.28e-12 P=599.28e-6
XRptap vss sub ptap1 A=2131.08e-12 P=2135.08e-6
XC0_0 net063 vout cap_cmim w=43.46u l=43.46u m=1
XC0_1 net063 vout cap_cmim w=43.46u l=43.46u m=1
XC0_2 net063 vout cap_cmim w=43.46u l=43.46u m=1
XC1_0 net050 net013 cap_cmim w=36.515u l=36.515u m=1
.ends amp_002_alfio_raffc
