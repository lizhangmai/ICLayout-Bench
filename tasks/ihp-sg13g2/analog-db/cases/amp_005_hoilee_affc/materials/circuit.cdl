* Derived from analog-db amp_005_hoilee_affc, fixed snapshot
* 263d0322f8900dc331536fbbe6c0e804514fc454. Copyright 2026 Danial Noori Zadeh.
* See collection LICENSE and NOTICE. Modified: process-grid dimensions, physical passives, explicit bias and separate body taps.
.subckt amp_005_hoilee_affc vss vdd vinn vinp vout net013
MM13 vb4 vb3 net54 sub sg13_lv_nmos w=0.21u l=3.15u m=16
MM14 dm_1 vb3 net56 sub sg13_lv_nmos w=0.21u l=3.15u m=16
MM15 vb3 vb3 vss sub sg13_lv_nmos w=0.21u l=3.15u m=4
MM16 voutn vb3 dm_2 sub sg13_lv_nmos w=2.9u l=8.24u m=16
MM17 net050 vb3 net063 sub sg13_lv_nmos w=2.9u l=8.24u m=16
MM18 net54 vb4 vss sub sg13_lv_nmos w=0.21u l=3.15u m=16
MM19 net56 vb4 vss sub sg13_lv_nmos w=0.21u l=3.15u m=16
MM20 dm_2 vb4 vss sub sg13_lv_nmos w=0.21u l=3.15u m=32
MM21 net063 vb4 vss sub sg13_lv_nmos w=0.21u l=3.15u m=32
MM22 net043 net043 vss sub sg13_lv_nmos w=6.34u l=9.33u m=4
MM23 net049 net043 vss sub sg13_lv_nmos w=6.34u l=9.33u m=4
MM25 vout net049 vss sub sg13_lv_nmos w=2.71u l=3.98u m=4
MM60 net2 vb3 net3 sub sg13_lv_nmos w=2.92u l=0.77u m=4
MM61 net3 vb4 vss sub sg13_lv_nmos w=0.21u l=3.15u m=16
MM63 net050 vb3 net1 sub sg13_lv_nmos w=2.92u l=0.77u m=4
MM64 net1 vb4 vss sub sg13_lv_nmos w=0.21u l=3.15u m=16
MM10 net063 vinp net31 well_net31 sg13_lv_pmos w=9.88u l=0.77u m=4
MM9 dm_2 vinn net31 well_net31 sg13_lv_pmos w=9.88u l=0.77u m=4
RRtap_net31 net31 well_net31 ntap1 A=104.32e-12 P=108.32e-6
MM0 net013 net013 vdd well_vdd sg13_lv_pmos w=2.17u l=6.86u m=4
MM1 vb4 net013 vdd well_vdd sg13_lv_pmos w=2.17u l=6.86u m=4
MM11 net043 net050 vdd well_vdd sg13_lv_pmos w=2.79u l=1.37u m=4
MM12 vout net050 vdd well_vdd sg13_lv_pmos w=8.69u l=0.6u m=4
MM2 dm_1 net013 vdd well_vdd sg13_lv_pmos w=2.17u l=6.86u m=4
MM3 vb3 net013 vdd well_vdd sg13_lv_pmos w=2.17u l=6.86u m=4
MM4 net31 net013 vdd well_vdd sg13_lv_pmos w=2.17u l=6.86u m=8
MM5 voutn voutn vdd well_vdd sg13_lv_pmos w=2.17u l=6.86u m=4
MM59 net2 net2 vdd well_vdd sg13_lv_pmos w=4.58u l=4.37u m=4
MM6 net050 voutn vdd well_vdd sg13_lv_pmos w=2.17u l=6.86u m=4
MM62 net050 net2 vdd well_vdd sg13_lv_pmos w=4.58u l=4.37u m=4
MM7 net049 net013 vdd well_vdd sg13_lv_pmos w=2.17u l=6.86u m=4
RRtap_vdd vdd well_vdd ntap1 A=1171.6e-12 P=1175.6e-6
RRptap vss sub ptap1 A=5357.92e-12 P=5361.92e-6
CC0_0 net049 vout cap_cmim w=44.775u l=44.775u m=1
CC0_1 net049 vout cap_cmim w=44.775u l=44.775u m=1
CC0_2 net049 vout cap_cmim w=44.775u l=44.775u m=1
CC0_3 net049 vout cap_cmim w=44.775u l=44.775u m=1
CC1_0 vout net1 cap_cmim w=49.965u l=49.965u m=1
CC1_1 vout net1 cap_cmim w=49.965u l=49.965u m=1
CC1_2 vout net1 cap_cmim w=49.965u l=49.965u m=1
.ends amp_005_hoilee_affc
