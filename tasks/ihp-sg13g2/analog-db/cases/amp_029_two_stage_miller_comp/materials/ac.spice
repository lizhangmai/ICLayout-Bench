* Differential Miller characterization; external differential feedback only.
.lib /workspace/support/models/cornerMOSlv.lib mos_tt
.lib /workspace/support/models/cornerCAP.lib cap_typ
.lib /workspace/support/models/cornerRES.lib res_typ
.include parameters.spice
.include dut.spice
.temp 27
.save v(vdd) v(vss) v(vp) v(vm) v(voutp) v(voutn) v(ref) v(vbl) i(vdd) i(vss) i(vbl) i(vp) i(vn)
VSS vss 0 0
.options reltol=1e-7 abstol=1e-14 vntol=1e-10
VDD vdd 0 1.2
IBIAS vdd ref 20u
VBL vbl 0 .7087
XDUT vp vm voutp voutn vdd vss ref vbl amp_029_two_stage_miller_comp
CP voutp 0 10p
CN voutn 0 10p
VP vp 0 dc .6 ac .5
VN vm 0 dc .6 ac .5 180

.control
set numdgt=15
set measdgt=15
op
let kcl_a=abs(i(vdd)+i(vss)+i(vbl)+i(vp)+i(vn))
print kcl_a
let output_cm_v=(v(voutp)+v(voutn))/2
let offset_v=v(voutp)-v(voutn)
let power_w=-v(vdd)*i(vdd)
print output_cm_v offset_v power_w
write op.raw all
ac dec 200 1 1g
let transfer=(v(voutp)-v(voutn))/(v(vp)-v(vm))
let gain_db_vec=db(transfer)
let fixture_cm_max=vecmax(mag((v(vp)+v(vm))/2))
meas ac gain_db find gain_db_vec at=1
meas ac gain_10khz_db find gain_db_vec at=10k
print fixture_cm_max
write ac.raw all
quit
.endc
.end
