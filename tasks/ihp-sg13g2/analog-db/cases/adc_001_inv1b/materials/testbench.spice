* Independently authored measurement fixture; SPDX-License-Identifier: MIT
.lib /workspace/support/models/cornerMOSlv.lib mos_tt
.lib /workspace/support/models/cornerRES.lib res_typ
.include dut.spice
.include parameters.spice
.options klu reltol=1e-6 abstol=1e-13 vntol=1e-9
.temp 27
VDD vdd 0 1.2
VSS vss 0 0
VIN drive 0 DC 0 PULSE(0 1.2 10n 100p 100p 10n 20n)
RS drive vin 50
CL vout 0 20f
XDUT vdd vin vout vss adc_001_inv1b
.control
set numdgt=15
set measdgt=15
op
let kcl_residual=abs(i(vdd)+i(vss)+i(vin))
if kcl_residual > 1e-10
  echo Error: external DC KCL failed
  quit 1
end
show all
write op.raw all
dc VIN 0 1.2 .001
let ncross=0
let idx=0
while idx < length(v(vout))-1
  if v(vout)[idx] > .6
    if v(vout)[idx+1] <= .6
      let ncross=ncross+1
    end
  end
  if v(vout)[idx] < .6
    if v(vout)[idx+1] >= .6
      let ncross=ncross+1
    end
  end
  let idx=idx+1
end
if ncross <> 1
  echo Error: ambiguous DC threshold crossing
  quit 1
end
meas dc threshold_v when v(vout)=.6 fall=1
meas dc high_v find v(vout) at=0
let low_v=v(vout)[length(v(vout))-1]
let swing_v=high_v-low_v
print swing_v
write dc.raw all
tran 1p 31n 0 1p
let nup=0
let ndown=0
let idx=0
while time[idx+1] < 29n
  if v(vin)[idx] < 0.6
    if v(vin)[idx+1] >= 0.6
      let nup=nup+1
    end
  end
  if v(vin)[idx] > 0.6
    if v(vin)[idx+1] <= 0.6
      let ndown=ndown+1
    end
  end
  let idx=idx+1
end
if nup <> 1
  echo Error: missing or multiple rising transitions
  quit 1
end
if ndown <> 1
  echo Error: missing or multiple falling transitions
  quit 1
end
let nup=0
let ndown=0
let idx=0
while time[idx+1] < 29n
  if v(vout)[idx] < 0.12
    if v(vout)[idx+1] >= 0.12
      let nup=nup+1
    end
  end
  if v(vout)[idx] > 0.12
    if v(vout)[idx+1] <= 0.12
      let ndown=ndown+1
    end
  end
  let idx=idx+1
end
if nup <> 1
  echo Error: missing or multiple rising transitions
  quit 1
end
if ndown <> 1
  echo Error: missing or multiple falling transitions
  quit 1
end
let nup=0
let ndown=0
let idx=0
while time[idx+1] < 29n
  if v(vout)[idx] < 0.6
    if v(vout)[idx+1] >= 0.6
      let nup=nup+1
    end
  end
  if v(vout)[idx] > 0.6
    if v(vout)[idx+1] <= 0.6
      let ndown=ndown+1
    end
  end
  let idx=idx+1
end
if nup <> 1
  echo Error: missing or multiple rising transitions
  quit 1
end
if ndown <> 1
  echo Error: missing or multiple falling transitions
  quit 1
end
let nup=0
let ndown=0
let idx=0
while time[idx+1] < 29n
  if v(vout)[idx] < 1.08
    if v(vout)[idx+1] >= 1.08
      let nup=nup+1
    end
  end
  if v(vout)[idx] > 1.08
    if v(vout)[idx+1] <= 1.08
      let ndown=ndown+1
    end
  end
  let idx=idx+1
end
if nup <> 1
  echo Error: missing or multiple rising transitions
  quit 1
end
if ndown <> 1
  echo Error: missing or multiple falling transitions
  quit 1
end
meas tran fall_delay trig v(vin) val=.6 rise=1 targ v(vout) val=.6 fall=1
meas tran rise_delay trig v(vin) val=.6 fall=1 targ v(vout) val=.6 rise=1
meas tran fall_time trig v(vout) val=1.08 fall=1 targ v(vout) val=.12 fall=1
meas tran rise_time trig v(vout) val=.12 rise=1 targ v(vout) val=1.08 rise=1
let delay_s=max(fall_delay,rise_delay)
let transition_s=max(fall_time,rise_time)
let power=-v(vdd)*i(vdd)-v(drive)*i(vin)
meas tran power_w avg power from=10n to=30n
print delay_s transition_s
write transient.raw all
quit
.endc
.end
