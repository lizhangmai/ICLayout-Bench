* Derived from analog-db buf_001_super_follower, fixed snapshot
* 263d0322f8900dc331536fbbe6c0e804514fc454. Copyright 2026 Danial Noori Zadeh.
* See collection LICENSE and NOTICE. Fixed dimensions and explicit physical taps.
* Internal 250 fF ideal compensation becomes a 12.85 um square physical MIM.
.subckt buf_001_super_follower vdd vout vin ibias vss
XM1 na vin vout sub sg13_lv_nmos w=8u l=0.3u m=4
XM2 vout na vss sub sg13_lv_nmos w=8u l=0.3u m=4
XMNS pd ibias vss sub sg13_lv_nmos w=4u l=0.3u m=1
XMRN ibias ibias vss sub sg13_lv_nmos w=4u l=0.3u m=1
XMPB na pd vdd well sg13_lv_pmos w=8u l=0.3u m=6
XMPD pd pd vdd well sg13_lv_pmos w=8u l=0.3u m=1
XRptap1 vss sub ptap1 A=216.2e-12 P=220.2e-6
XRntap1 vdd well ntap1 A=86.2e-12 P=90.2e-6
XCcomp na vss cap_cmim w=12.85u l=12.85u m=1
.ends buf_001_super_follower
