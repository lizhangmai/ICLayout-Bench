* Native regulator loop and load recovery. SPDX-License-Identifier: MIT
.lib /workspace/support/models/cornerMOSlv.lib mos_tt
.lib /workspace/support/models/cornerCAP.lib cap_typ
.lib /workspace/support/models/cornerRES.lib res_typ
.include parameters.spice
.include dut.spice
.temp 27
.option rshunt=1e12 reltol=1e-5 abstol=1e-14 vntol=1e-8 method=gear maxord=2
VDD vdd 0 {supply_v}
VREF vref 0 0.5
IBIAS vdd nbias 20u
VPROBE sense fb dc 0 ac 1
IINJ 0 sense dc 0 ac 0
ILOAD vout 0 dc {load_a} pulse({load_a} {load_a+1u} 1n 5p 5p 1n 200n)
XDUT vdd vout 0 nbias vref fb sense ldo_008_fer_mirror_ota
.control
set numdgt=12
op
let baseline_v=v(vout)
tran 5p 100n 0 5p
let error_v=abs(v(vout)-op1.baseline_v)
meas tran fast_peak_v max error_v from=0 to=100n
meas tran fast_tail_v max error_v from=80n to=100n
write transient.raw v(vout) v(vdd) i(VDD) error_v
quit
.endc
.end
