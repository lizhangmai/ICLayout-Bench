* Native regulator loop and load recovery. SPDX-License-Identifier: MIT
.lib /workspace/support/models/cornerMOSlv.lib mos_tt
.lib /workspace/support/models/cornerCAP.lib cap_typ
.lib /workspace/support/models/cornerRES.lib res_typ
.include parameters.spice
.include dut.spice
.temp 27
.option rshunt=1e12 reltol=1e-5 abstol=1e-14 vntol=1e-8 method=gear maxord=2
VDD vdd 0 {supply_v}
VREF vref 0 0.5
IBIAS vdd nbias 20u
VPROBE sense fb dc 0 ac 1
IINJ 0 sense dc 0 ac 0
ILOAD vout 0 dc {load_a} pulse({load_a} {2*load_a} 2u 20n 20n 8u 16u)
XDUT vdd vout 0 nbias vref fb sense ldo_008_fer_mirror_ota
.control
set numdgt=12
op
let output_v=v(vout)
let power_w=-v(vdd)*i(VDD)
let quiescent_a=-i(VDD)-@iload[current]
let bias_v=v(nbias)
print output_v power_w quiescent_a bias_v
write op.raw v(vout) v(nbias) i(VDD) @iload[current]
ac dec 300 0.01 1g
let bv=-i(VPROBE)
let dv=v(sense)
let oldratio=-v(fb)/v(sense)
write voltage.raw frequency v(sense) v(fb) i(VPROBE)
alter VPROBE acmag=0
alter IINJ acmag=1
ac dec 300 0.01 1g
let aa=-i(VPROBE)
let cc=v(sense)
let bb=ac1.bv
let dd=ac1.dv
let delta=aa*dd-bb*cc
let denominator=1-2*delta+aa-dd
let transfer=(2*delta-aa+dd)/denominator
let forward=(delta-aa)/denominator
let reverse=(delta+dd)/denominator
let gain_db=db(transfer)
let phase_deg=180*cph(transfer)/pi
meas ac dc_gain_db find gain_db at=0.01
meas ac unity_hz when gain_db=0 fall=1
meas ac phase_at_unity find phase_deg when gain_db=0 fall=1
let phase_margin_deg=180+phase_at_unity
print phase_margin_deg
let return_distance=mag(1+transfer)
let minimum_return_distance=vecmin(return_distance)
meas ac hf_gain_db max gain_db from=200meg to=1g
let return_phase_excursion_deg=vecmax(abs(180*cph(1+transfer)/pi))
meas ac final_unity_hz when gain_db=0 fall=last
meas ac phase_at_final find phase_deg when gain_db=0 fall=last
let final_phase_margin_deg=180+phase_at_final
print minimum_return_distance return_phase_excursion_deg final_phase_margin_deg
write ac.raw frequency v(sense) v(fb) i(VPROBE) aa bb cc dd transfer forward reverse gain_db phase_deg
reset

tran 1n 18u 0 1n
let err=abs(v(vout)-1.0)
let supply=-v(vdd)*i(VDD)
meas tran minimum_v min v(vout) from=2u to=18u
meas tran maximum_v max v(vout) from=2u to=18u
meas tran recovery_load_v max err from=5u to=9.5u
meas tran recovery_release_v max err from=13u to=17.5u
meas tran mean_power_w avg supply from=2u to=18u
write transient.raw v(vout) v(vdd) i(VDD)
quit
.endc
.end
