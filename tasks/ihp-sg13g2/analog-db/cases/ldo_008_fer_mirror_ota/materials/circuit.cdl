* Derived from analog-db ldo_008_fer_mirror_ota, fixed snapshot
* 263d0322f8900dc331536fbbe6c0e804514fc454. Copyright 2026 Danial Noori Zadeh.
* See collection LICENSE and NOTICE. Modified: physical MIM/poly and taps; separate divider/sense measurement ports.
.subckt ldo_008_fer_mirror_ota vdd vout vss nbias vref fb sense
MMDF ldiode sense tail sub sg13_lv_nmos w=6u l=0.3u m=4
MMDR egate vref tail sub sg13_lv_nmos w=6u l=0.3u m=4
MMNB nbias nbias vss sub sg13_lv_nmos w=8u l=0.5u m=1
MMNT tail nbias vss sub sg13_lv_nmos w=8u l=0.5u m=4
MMLD ldiode ldiode vdd well_vdd sg13_lv_pmos w=8u l=0.5u m=4
MMLM egate ldiode vdd well_vdd sg13_lv_pmos w=8u l=0.5u m=4
MMP vout egate vdd well_vdd sg13_lv_pmos w=8u l=0.2u m=60
RRtap_vdd vdd well_vdd ntap1 A=730e-12 P=734e-6
RRptap vss sub ptap1 A=941.8e-12 P=945.8e-6
CCC_0 czero vout cap_cmim w=51.64u l=51.64u m=1
CCC_1 czero vout cap_cmim w=51.64u l=51.64u m=1
CCC_2 czero vout cap_cmim w=51.64u l=51.64u m=1
CCC_3 czero vout cap_cmim w=51.64u l=51.64u m=1
CCC_4 czero vout cap_cmim w=51.64u l=51.64u m=1
CCC_5 czero vout cap_cmim w=51.64u l=51.64u m=1
CCC_6 czero vout cap_cmim w=51.64u l=51.64u m=1
CCC_7 czero vout cap_cmim w=51.64u l=51.64u m=1
CCC_8 czero vout cap_cmim w=51.64u l=51.64u m=1
CCC_9 czero vout cap_cmim w=51.64u l=51.64u m=1
CCC_10 czero vout cap_cmim w=51.64u l=51.64u m=1
CCC_11 czero vout cap_cmim w=51.64u l=51.64u m=1
CCC_12 czero vout cap_cmim w=51.64u l=51.64u m=1
CCC_13 czero vout cap_cmim w=51.64u l=51.64u m=1
CCC_14 czero vout cap_cmim w=51.64u l=51.64u m=1
CCC_15 czero vout cap_cmim w=51.64u l=51.64u m=1
CCC_16 czero vout cap_cmim w=51.64u l=51.64u m=1
CCC_17 czero vout cap_cmim w=51.64u l=51.64u m=1
CCC_18 czero vout cap_cmim w=51.64u l=51.64u m=1
CCC_19 czero vout cap_cmim w=51.64u l=51.64u m=1
CCC_20 czero vout cap_cmim w=51.64u l=51.64u m=1
CCC_21 czero vout cap_cmim w=51.64u l=51.64u m=1
CCC_22 czero vout cap_cmim w=51.64u l=51.64u m=1
CCC_23 czero vout cap_cmim w=51.64u l=51.64u m=1
CCC_24 czero vout cap_cmim w=51.64u l=51.64u m=1
CCC_25 czero vout cap_cmim w=51.64u l=51.64u m=1
CCC_26 czero vout cap_cmim w=51.64u l=51.64u m=1
CCC_27 czero vout cap_cmim w=51.64u l=51.64u m=1
CCC_28 czero vout cap_cmim w=51.64u l=51.64u m=1
CCC_29 czero vout cap_cmim w=51.64u l=51.64u m=1
CCC_30 czero vout cap_cmim w=51.64u l=51.64u m=1
CCC_31 czero vout cap_cmim w=51.64u l=51.64u m=1
CCC_32 czero vout cap_cmim w=51.64u l=51.64u m=1
CCC_33 czero vout cap_cmim w=51.64u l=51.64u m=1
CCC_34 czero vout cap_cmim w=51.64u l=51.64u m=1
CCC_35 czero vout cap_cmim w=51.64u l=51.64u m=1
CCC_36 czero vout cap_cmim w=51.64u l=51.64u m=1
CCC_37 czero vout cap_cmim w=51.64u l=51.64u m=1
CCC_38 czero vout cap_cmim w=51.64u l=51.64u m=1
CCC_39 czero vout cap_cmim w=51.64u l=51.64u m=1
RRB_0 fb vss sub rhigh w=1u l=6.235u m=1 b=0
RRC_0 egate czero sub rhigh w=1u l=1.325u m=1 b=0
RRT_0 vout fb sub rhigh w=1u l=6.235u m=1 b=0
.ends ldo_008_fer_mirror_ota
