* analog-db amp_001_5t, fixed IHP binding at 263d0322f8900dc331536fbbe6c0e804514fc454.
* Copyright 2026 Danial Noori Zadeh. See collection LICENSE and NOTICE.
* Layout-Bench changes: resolve parameter ties/defaults; explicit physical taps;
* fixed interface and native LVS cards in circuit.cdl, model calls in circuit.spice.
.subckt amp_001_5t vdd vout vinp vinn ibias vss
MM1 outm vinp tail sub sg13_lv_nmos w=10u l=10u m=1
MM2 vout vinn tail sub sg13_lv_nmos w=10u l=10u m=1
MM3 outm outm vdd well sg13_lv_pmos w=10u l=7u m=1
MM4 vout outm vdd well sg13_lv_pmos w=10u l=7u m=1
MM5 tail ibias vss sub sg13_lv_nmos w=3.8u l=1u m=1
MM6 ibias ibias vss sub sg13_lv_nmos w=3.8u l=1u m=1
RR1 vss sub ptap1 A=192e-12 P=196e-6
RR2 vdd well ntap1 A=52e-12 P=56e-6
.ends amp_001_5t
