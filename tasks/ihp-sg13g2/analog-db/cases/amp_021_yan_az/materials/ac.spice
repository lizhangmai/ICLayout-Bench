* Same-condition finite-window amplifier observations. SPDX-License-Identifier: MIT
.lib /workspace/support/models/cornerMOSlv.lib mos_tt
.lib /workspace/support/models/cornerCAP.lib cap_typ
.lib /workspace/support/models/cornerRES.lib res_typ
.include parameters.spice
.include dut.spice
.temp 27
.save v(vdd) v(vout) v(vp) v(vm) v(net1) i(VDD)
.options rshunt=1e12 reltol=1e-7 abstol=1e-14 vntol=1e-10 method=gear maxord=2 itl4=1000
VDD vdd 0 1.5
VIN vp 0 dc 0.3 ac 0.5
IBIAS net1 0 1.0981e-5
LFB vout basem 1T
CFB basem 0 1
VNEG vm basem dc 0 ac 0.5 180
XDUT 0 vdd vm vp vout net1 amp_021_yan_az
CLOAD vout 0 {load_f}
.control
set noaskquit
set num_threads=1
set numdgt=15
op
let dc_feedback_error_v=abs(v(vout)-v(vm))
print dc_feedback_error_v
if dc_feedback_error_v > 1e-6
  echo Error: invalid DC feedback operating point
  quit 1
end
write op.raw all
ac dec 200 1 1g
let transfer=v(vout)/(v(vp)-v(vm))
let gain_db_vec=db(transfer)
let fixture_cm_max=vecmax(mag((v(vp)+v(vm))/2))
meas ac gain_db find gain_db_vec at=1
meas ac gain_10khz_db find gain_db_vec at=10k
print fixture_cm_max
if fixture_cm_max > 1e-6
  echo Error: invalid differential AC excitation
  quit 1
end
write ac.raw all
quit
.endc
.end
