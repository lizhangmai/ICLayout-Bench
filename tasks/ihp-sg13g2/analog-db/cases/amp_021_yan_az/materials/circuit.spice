* Copyright 2026 Danial Noori Zadeh. See collection LICENSE and NOTICE.
* Fixed IHP binding; external bias ports and native physical taps.
.subckt amp_021_yan_az vss vdd vinn vinp vout vb1
XT0 vdd well_0 ntap1 A=4e-12 P=8e-6
XM0_0 vb1 vb1 vdd well_0 sg13_lv_pmos w=0.54u l=3.85u m=1
XT1 vdd well_1 ntap1 A=4e-12 P=8e-6
XM0_1 vb1 vb1 vdd well_1 sg13_lv_pmos w=0.54u l=3.85u m=1
XT2 vdd well_2 ntap1 A=4e-12 P=8e-6
XM0_2 vb1 vb1 vdd well_2 sg13_lv_pmos w=0.54u l=3.85u m=1
XT3 vdd well_3 ntap1 A=4e-12 P=8e-6
XM0_3 vb1 vb1 vdd well_3 sg13_lv_pmos w=0.54u l=3.85u m=1
XT4 vdd well_4 ntap1 A=4e-12 P=8e-6
XM1_0 vb4 vb1 vdd well_4 sg13_lv_pmos w=0.54u l=3.85u m=1
XT5 vdd well_5 ntap1 A=4e-12 P=8e-6
XM1_1 vb4 vb1 vdd well_5 sg13_lv_pmos w=0.54u l=3.85u m=1
XT6 vdd well_6 ntap1 A=4e-12 P=8e-6
XM1_2 vb4 vb1 vdd well_6 sg13_lv_pmos w=0.54u l=3.85u m=1
XT7 vdd well_7 ntap1 A=4e-12 P=8e-6
XM1_3 vb4 vb1 vdd well_7 sg13_lv_pmos w=0.54u l=3.85u m=1
XT8 net019 well_8 ntap1 A=4e-12 P=8e-6
XM10_0 net063 vinp net019 well_8 sg13_lv_pmos w=2.59u l=0.37u m=1
XT9 net019 well_9 ntap1 A=4e-12 P=8e-6
XM10_1 net063 vinp net019 well_9 sg13_lv_pmos w=2.59u l=0.37u m=1
XT10 net019 well_10 ntap1 A=4e-12 P=8e-6
XM10_2 net063 vinp net019 well_10 sg13_lv_pmos w=2.59u l=0.37u m=1
XT11 net019 well_11 ntap1 A=4e-12 P=8e-6
XM10_3 net063 vinp net019 well_11 sg13_lv_pmos w=2.59u l=0.37u m=1
XT12 vdd well_12 ntap1 A=4e-12 P=8e-6
XM11_0 net094 net050 vdd well_12 sg13_lv_pmos w=8.95u l=3.41u m=1
XT13 vdd well_13 ntap1 A=4e-12 P=8e-6
XM11_1 net094 net050 vdd well_13 sg13_lv_pmos w=8.95u l=3.41u m=1
XT14 vdd well_14 ntap1 A=4e-12 P=8e-6
XM11_2 net094 net050 vdd well_14 sg13_lv_pmos w=8.95u l=3.41u m=1
XT15 vdd well_15 ntap1 A=4e-12 P=8e-6
XM11_3 net094 net050 vdd well_15 sg13_lv_pmos w=8.95u l=3.41u m=1
XT16 vdd well_16 ntap1 A=4e-12 P=8e-6
XM13_0 vout net050 vdd well_16 sg13_lv_pmos w=5.99u l=2.04u m=1
XT17 vdd well_17 ntap1 A=4e-12 P=8e-6
XM13_1 vout net050 vdd well_17 sg13_lv_pmos w=5.99u l=2.04u m=1
XT18 vdd well_18 ntap1 A=4e-12 P=8e-6
XM13_2 vout net050 vdd well_18 sg13_lv_pmos w=5.99u l=2.04u m=1
XT19 vdd well_19 ntap1 A=4e-12 P=8e-6
XM13_3 vout net050 vdd well_19 sg13_lv_pmos w=5.99u l=2.04u m=1
XT20 vss sub ptap1 A=4e-12 P=8e-6
XM14_0 voutn net077 dm_2 sub sg13_lv_nmos w=9.12u l=7.48u m=1
XT21 vss sub ptap1 A=4e-12 P=8e-6
XM14_1 voutn net077 dm_2 sub sg13_lv_nmos w=9.12u l=7.48u m=1
XT22 vss sub ptap1 A=4e-12 P=8e-6
XM14_2 voutn net077 dm_2 sub sg13_lv_nmos w=9.12u l=7.48u m=1
XT23 vss sub ptap1 A=4e-12 P=8e-6
XM14_3 voutn net077 dm_2 sub sg13_lv_nmos w=9.12u l=7.48u m=1
XT24 vss sub ptap1 A=4e-12 P=8e-6
XM15_0 net050 net082 net063 sub sg13_lv_nmos w=9.12u l=7.48u m=1
XT25 vss sub ptap1 A=4e-12 P=8e-6
XM15_1 net050 net082 net063 sub sg13_lv_nmos w=9.12u l=7.48u m=1
XT26 vss sub ptap1 A=4e-12 P=8e-6
XM15_2 net050 net082 net063 sub sg13_lv_nmos w=9.12u l=7.48u m=1
XT27 vss sub ptap1 A=4e-12 P=8e-6
XM15_3 net050 net082 net063 sub sg13_lv_nmos w=9.12u l=7.48u m=1
XT28 vss sub ptap1 A=4e-12 P=8e-6
XM16_0 net077 dm_2 vss sub sg13_lv_nmos w=2.64u l=5.64u m=1
XT29 vss sub ptap1 A=4e-12 P=8e-6
XM16_1 net077 dm_2 vss sub sg13_lv_nmos w=2.64u l=5.64u m=1
XT30 vss sub ptap1 A=4e-12 P=8e-6
XM16_2 net077 dm_2 vss sub sg13_lv_nmos w=2.64u l=5.64u m=1
XT31 vss sub ptap1 A=4e-12 P=8e-6
XM16_3 net077 dm_2 vss sub sg13_lv_nmos w=2.64u l=5.64u m=1
XT32 vss sub ptap1 A=4e-12 P=8e-6
XM17_0 net082 net063 vss sub sg13_lv_nmos w=2.64u l=5.64u m=1
XT33 vss sub ptap1 A=4e-12 P=8e-6
XM17_1 net082 net063 vss sub sg13_lv_nmos w=2.64u l=5.64u m=1
XT34 vss sub ptap1 A=4e-12 P=8e-6
XM17_2 net082 net063 vss sub sg13_lv_nmos w=2.64u l=5.64u m=1
XT35 vss sub ptap1 A=4e-12 P=8e-6
XM17_3 net082 net063 vss sub sg13_lv_nmos w=2.64u l=5.64u m=1
XT36 vss sub ptap1 A=4e-12 P=8e-6
XM18_0 vout net057 vss sub sg13_lv_nmos w=0.41u l=3u m=1
XT37 vss sub ptap1 A=4e-12 P=8e-6
XM18_1 vout net057 vss sub sg13_lv_nmos w=0.41u l=3u m=1
XT38 vss sub ptap1 A=4e-12 P=8e-6
XM18_2 vout net057 vss sub sg13_lv_nmos w=0.41u l=3u m=1
XT39 vss sub ptap1 A=4e-12 P=8e-6
XM18_3 vout net057 vss sub sg13_lv_nmos w=0.41u l=3u m=1
XT40 vss sub ptap1 A=4e-12 P=8e-6
XM19_0 vb4 vb4 vss sub sg13_lv_nmos w=2.01u l=1.26u m=1
XT41 vss sub ptap1 A=4e-12 P=8e-6
XM19_1 vb4 vb4 vss sub sg13_lv_nmos w=2.01u l=1.26u m=1
XT42 vss sub ptap1 A=4e-12 P=8e-6
XM19_2 vb4 vb4 vss sub sg13_lv_nmos w=2.01u l=1.26u m=1
XT43 vss sub ptap1 A=4e-12 P=8e-6
XM19_3 vb4 vb4 vss sub sg13_lv_nmos w=2.01u l=1.26u m=1
XT44 vdd well_44 ntap1 A=4e-12 P=8e-6
XM2_0 net019 vb1 vdd well_44 sg13_lv_pmos w=0.54u l=3.85u m=1
XT45 vdd well_45 ntap1 A=4e-12 P=8e-6
XM2_1 net019 vb1 vdd well_45 sg13_lv_pmos w=0.54u l=3.85u m=1
XT46 vdd well_46 ntap1 A=4e-12 P=8e-6
XM2_2 net019 vb1 vdd well_46 sg13_lv_pmos w=0.54u l=3.85u m=1
XT47 vdd well_47 ntap1 A=4e-12 P=8e-6
XM2_3 net019 vb1 vdd well_47 sg13_lv_pmos w=0.54u l=3.85u m=1
XT48 vdd well_48 ntap1 A=4e-12 P=8e-6
XM2_4 net019 vb1 vdd well_48 sg13_lv_pmos w=0.54u l=3.85u m=1
XT49 vdd well_49 ntap1 A=4e-12 P=8e-6
XM2_5 net019 vb1 vdd well_49 sg13_lv_pmos w=0.54u l=3.85u m=1
XT50 vdd well_50 ntap1 A=4e-12 P=8e-6
XM2_6 net019 vb1 vdd well_50 sg13_lv_pmos w=0.54u l=3.85u m=1
XT51 vdd well_51 ntap1 A=4e-12 P=8e-6
XM2_7 net019 vb1 vdd well_51 sg13_lv_pmos w=0.54u l=3.85u m=1
XT52 vss sub ptap1 A=4e-12 P=8e-6
XM20_0 dm_2 vb4 vss sub sg13_lv_nmos w=2.01u l=1.26u m=1
XT53 vss sub ptap1 A=4e-12 P=8e-6
XM20_1 dm_2 vb4 vss sub sg13_lv_nmos w=2.01u l=1.26u m=1
XT54 vss sub ptap1 A=4e-12 P=8e-6
XM20_2 dm_2 vb4 vss sub sg13_lv_nmos w=2.01u l=1.26u m=1
XT55 vss sub ptap1 A=4e-12 P=8e-6
XM20_3 dm_2 vb4 vss sub sg13_lv_nmos w=2.01u l=1.26u m=1
XT56 vss sub ptap1 A=4e-12 P=8e-6
XM21_0 net063 vb4 vss sub sg13_lv_nmos w=2.01u l=1.26u m=1
XT57 vss sub ptap1 A=4e-12 P=8e-6
XM21_1 net063 vb4 vss sub sg13_lv_nmos w=2.01u l=1.26u m=1
XT58 vss sub ptap1 A=4e-12 P=8e-6
XM21_2 net063 vb4 vss sub sg13_lv_nmos w=2.01u l=1.26u m=1
XT59 vss sub ptap1 A=4e-12 P=8e-6
XM21_3 net063 vb4 vss sub sg13_lv_nmos w=2.01u l=1.26u m=1
XT60 vss sub ptap1 A=4e-12 P=8e-6
XM22_0 net094 net051 vss sub sg13_lv_nmos w=6.13u l=2.09u m=1
XT61 vss sub ptap1 A=4e-12 P=8e-6
XM22_1 net094 net051 vss sub sg13_lv_nmos w=6.13u l=2.09u m=1
XT62 vss sub ptap1 A=4e-12 P=8e-6
XM22_2 net094 net051 vss sub sg13_lv_nmos w=6.13u l=2.09u m=1
XT63 vss sub ptap1 A=4e-12 P=8e-6
XM22_3 net094 net051 vss sub sg13_lv_nmos w=6.13u l=2.09u m=1
XT64 vss sub ptap1 A=4e-12 P=8e-6
XM23_0 net057 net094 vss sub sg13_lv_nmos w=5.95u l=9.97u m=1
XT65 vss sub ptap1 A=4e-12 P=8e-6
XM23_1 net057 net094 vss sub sg13_lv_nmos w=5.95u l=9.97u m=1
XT66 vss sub ptap1 A=4e-12 P=8e-6
XM23_2 net057 net094 vss sub sg13_lv_nmos w=5.95u l=9.97u m=1
XT67 vss sub ptap1 A=4e-12 P=8e-6
XM23_3 net057 net094 vss sub sg13_lv_nmos w=5.95u l=9.97u m=1
XT68 vdd well_68 ntap1 A=4e-12 P=8e-6
XM3_0 net078 vb1 vdd well_68 sg13_lv_pmos w=0.54u l=3.85u m=1
XT69 vdd well_69 ntap1 A=4e-12 P=8e-6
XM3_1 net078 vb1 vdd well_69 sg13_lv_pmos w=0.54u l=3.85u m=1
XT70 vdd well_70 ntap1 A=4e-12 P=8e-6
XM3_2 net078 vb1 vdd well_70 sg13_lv_pmos w=0.54u l=3.85u m=1
XT71 vdd well_71 ntap1 A=4e-12 P=8e-6
XM3_3 net078 vb1 vdd well_71 sg13_lv_pmos w=0.54u l=3.85u m=1
XT72 vdd well_72 ntap1 A=4e-12 P=8e-6
XM3_4 net078 vb1 vdd well_72 sg13_lv_pmos w=0.54u l=3.85u m=1
XT73 vdd well_73 ntap1 A=4e-12 P=8e-6
XM3_5 net078 vb1 vdd well_73 sg13_lv_pmos w=0.54u l=3.85u m=1
XT74 vdd well_74 ntap1 A=4e-12 P=8e-6
XM3_6 net078 vb1 vdd well_74 sg13_lv_pmos w=0.54u l=3.85u m=1
XT75 vdd well_75 ntap1 A=4e-12 P=8e-6
XM3_7 net078 vb1 vdd well_75 sg13_lv_pmos w=0.54u l=3.85u m=1
XT76 vdd well_76 ntap1 A=4e-12 P=8e-6
XM3_8 net078 vb1 vdd well_76 sg13_lv_pmos w=0.54u l=3.85u m=1
XT77 vdd well_77 ntap1 A=4e-12 P=8e-6
XM3_9 net078 vb1 vdd well_77 sg13_lv_pmos w=0.54u l=3.85u m=1
XT78 vdd well_78 ntap1 A=4e-12 P=8e-6
XM3_10 net078 vb1 vdd well_78 sg13_lv_pmos w=0.54u l=3.85u m=1
XT79 vdd well_79 ntap1 A=4e-12 P=8e-6
XM3_11 net078 vb1 vdd well_79 sg13_lv_pmos w=0.54u l=3.85u m=1
XT80 vdd well_80 ntap1 A=4e-12 P=8e-6
XM3_12 net078 vb1 vdd well_80 sg13_lv_pmos w=0.54u l=3.85u m=1
XT81 vdd well_81 ntap1 A=4e-12 P=8e-6
XM3_13 net078 vb1 vdd well_81 sg13_lv_pmos w=0.54u l=3.85u m=1
XT82 vdd well_82 ntap1 A=4e-12 P=8e-6
XM3_14 net078 vb1 vdd well_82 sg13_lv_pmos w=0.54u l=3.85u m=1
XT83 vdd well_83 ntap1 A=4e-12 P=8e-6
XM3_15 net078 vb1 vdd well_83 sg13_lv_pmos w=0.54u l=3.85u m=1
XT84 vdd well_84 ntap1 A=4e-12 P=8e-6
XM4_0 voutn voutn vdd well_84 sg13_lv_pmos w=0.54u l=3.85u m=1
XT85 vdd well_85 ntap1 A=4e-12 P=8e-6
XM4_1 voutn voutn vdd well_85 sg13_lv_pmos w=0.54u l=3.85u m=1
XT86 vdd well_86 ntap1 A=4e-12 P=8e-6
XM4_2 voutn voutn vdd well_86 sg13_lv_pmos w=0.54u l=3.85u m=1
XT87 vdd well_87 ntap1 A=4e-12 P=8e-6
XM4_3 voutn voutn vdd well_87 sg13_lv_pmos w=0.54u l=3.85u m=1
XT88 vdd well_88 ntap1 A=4e-12 P=8e-6
XM5_0 net050 voutn vdd well_88 sg13_lv_pmos w=0.54u l=3.85u m=1
XT89 vdd well_89 ntap1 A=4e-12 P=8e-6
XM5_1 net050 voutn vdd well_89 sg13_lv_pmos w=0.54u l=3.85u m=1
XT90 vdd well_90 ntap1 A=4e-12 P=8e-6
XM5_2 net050 voutn vdd well_90 sg13_lv_pmos w=0.54u l=3.85u m=1
XT91 vdd well_91 ntap1 A=4e-12 P=8e-6
XM5_3 net050 voutn vdd well_91 sg13_lv_pmos w=0.54u l=3.85u m=1
XT92 vdd well_92 ntap1 A=4e-12 P=8e-6
XM67_0 net057 voutn vdd well_92 sg13_lv_pmos w=0.54u l=3.85u m=1
XT93 vdd well_93 ntap1 A=4e-12 P=8e-6
XM67_1 net057 voutn vdd well_93 sg13_lv_pmos w=0.54u l=3.85u m=1
XT94 vdd well_94 ntap1 A=4e-12 P=8e-6
XM67_2 net057 voutn vdd well_94 sg13_lv_pmos w=0.54u l=3.85u m=1
XT95 vdd well_95 ntap1 A=4e-12 P=8e-6
XM67_3 net057 voutn vdd well_95 sg13_lv_pmos w=0.54u l=3.85u m=1
XT96 net019 well_96 ntap1 A=4e-12 P=8e-6
XM9_0 dm_2 vinn net019 well_96 sg13_lv_pmos w=2.59u l=0.37u m=1
XT97 net019 well_97 ntap1 A=4e-12 P=8e-6
XM9_1 dm_2 vinn net019 well_97 sg13_lv_pmos w=2.59u l=0.37u m=1
XT98 net019 well_98 ntap1 A=4e-12 P=8e-6
XM9_2 dm_2 vinn net019 well_98 sg13_lv_pmos w=2.59u l=0.37u m=1
XT99 net019 well_99 ntap1 A=4e-12 P=8e-6
XM9_3 dm_2 vinn net019 well_99 sg13_lv_pmos w=2.59u l=0.37u m=1
XTSUB vss sub ptap1 A=4e-12 P=8e-6
XC0_0 net063 vout cap_cmim w=36.86u l=36.86u m=1
XC0_1 net063 vout cap_cmim w=36.86u l=36.86u m=1
XC1_0 net051 vss cap_cmim w=46.99u l=46.99u m=1
XC1_1 net051 vss cap_cmim w=46.99u l=46.99u m=1
XR0_0 net078 R0_s1 sub rhigh w=.5u l=61.2u m=1 b=0
XR0_1 R0_s1 net077 sub rhigh w=.5u l=61.2u m=1 b=0
XR1_0 net078 net082 sub rhigh w=.5u l=19.43u m=1 b=0
XR2_0 net094 R2_s1 sub rhigh w=.5u l=79.64u m=1 b=0
XR2_1 R2_s1 R2_s2 sub rhigh w=.5u l=79.64u m=1 b=0
XR2_2 R2_s2 R2_s3 sub rhigh w=.5u l=79.64u m=1 b=0
XR2_3 R2_s3 R2_s4 sub rhigh w=.5u l=79.64u m=1 b=0
XR2_4 R2_s4 R2_s5 sub rhigh w=.5u l=79.64u m=1 b=0
XR2_5 R2_s5 R2_s6 sub rhigh w=.5u l=79.64u m=1 b=0
XR2_6 R2_s6 net051 sub rhigh w=.5u l=79.64u m=1 b=0
.ends amp_021_yan_az
