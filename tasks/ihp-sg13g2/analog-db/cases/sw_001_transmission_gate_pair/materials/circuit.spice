* Copyright 2026 Danial Noori Zadeh. See collection LICENSE and NOTICE.
* Fixed IHP binding; external bias ports and native physical taps.
.subckt sw_001_transmission_gate_pair port_a port_b vctl vctl_not vdd vss
XT0 vss sub ptap1 A=4e-12 P=8e-6
XM1 port_a vctl port_b sub sg13_lv_nmos w=2u l=0.13u m=1
XT1 vdd well_1 ntap1 A=4e-12 P=8e-6
XM2 port_b vctl_not port_a well_1 sg13_lv_pmos w=2u l=0.13u m=1
XTSUB vss sub ptap1 A=4e-12 P=8e-6
.ends sw_001_transmission_gate_pair
