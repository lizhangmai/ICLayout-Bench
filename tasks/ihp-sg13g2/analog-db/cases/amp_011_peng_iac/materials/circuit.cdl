* Copyright 2026 Danial Noori Zadeh. See collection LICENSE and NOTICE.
* Fixed IHP binding; external bias ports and native physical taps.
.subckt amp_011_peng_iac vss vdd vinn vinp vout vb1
RT0 vdd well_0 ntap1 A=4e-12 P=8e-6
MM0_0 net2 vb1 vdd well_0 sg13_lv_pmos w=2.22u l=0.84u m=1
RT1 vdd well_1 ntap1 A=4e-12 P=8e-6
MM0_1 net2 vb1 vdd well_1 sg13_lv_pmos w=2.22u l=0.84u m=1
RT2 vdd well_2 ntap1 A=4e-12 P=8e-6
MM0_2 net2 vb1 vdd well_2 sg13_lv_pmos w=2.22u l=0.84u m=1
RT3 vdd well_3 ntap1 A=4e-12 P=8e-6
MM0_3 net2 vb1 vdd well_3 sg13_lv_pmos w=2.22u l=0.84u m=1
RT4 vdd well_4 ntap1 A=4e-12 P=8e-6
MM0_4 net2 vb1 vdd well_4 sg13_lv_pmos w=2.22u l=0.84u m=1
RT5 vdd well_5 ntap1 A=4e-12 P=8e-6
MM0_5 net2 vb1 vdd well_5 sg13_lv_pmos w=2.22u l=0.84u m=1
RT6 vdd well_6 ntap1 A=4e-12 P=8e-6
MM0_6 net2 vb1 vdd well_6 sg13_lv_pmos w=2.22u l=0.84u m=1
RT7 vdd well_7 ntap1 A=4e-12 P=8e-6
MM0_7 net2 vb1 vdd well_7 sg13_lv_pmos w=2.22u l=0.84u m=1
RT8 vdd well_8 ntap1 A=4e-12 P=8e-6
MM0_8 net2 vb1 vdd well_8 sg13_lv_pmos w=2.22u l=0.84u m=1
RT9 vdd well_9 ntap1 A=4e-12 P=8e-6
MM0_9 net2 vb1 vdd well_9 sg13_lv_pmos w=2.22u l=0.84u m=1
RT10 vdd well_10 ntap1 A=4e-12 P=8e-6
MM0_10 net2 vb1 vdd well_10 sg13_lv_pmos w=2.22u l=0.84u m=1
RT11 vdd well_11 ntap1 A=4e-12 P=8e-6
MM0_11 net2 vb1 vdd well_11 sg13_lv_pmos w=2.22u l=0.84u m=1
RT12 vdd well_12 ntap1 A=4e-12 P=8e-6
MM0_12 net2 vb1 vdd well_12 sg13_lv_pmos w=2.22u l=0.84u m=1
RT13 vdd well_13 ntap1 A=4e-12 P=8e-6
MM0_13 net2 vb1 vdd well_13 sg13_lv_pmos w=2.22u l=0.84u m=1
RT14 vdd well_14 ntap1 A=4e-12 P=8e-6
MM0_14 net2 vb1 vdd well_14 sg13_lv_pmos w=2.22u l=0.84u m=1
RT15 vdd well_15 ntap1 A=4e-12 P=8e-6
MM0_15 net2 vb1 vdd well_15 sg13_lv_pmos w=2.22u l=0.84u m=1
RT16 vdd well_16 ntap1 A=4e-12 P=8e-6
MM1_0 net3 vb1 vdd well_16 sg13_lv_pmos w=2.22u l=0.84u m=1
RT17 vdd well_17 ntap1 A=4e-12 P=8e-6
MM1_1 net3 vb1 vdd well_17 sg13_lv_pmos w=2.22u l=0.84u m=1
RT18 vdd well_18 ntap1 A=4e-12 P=8e-6
MM1_2 net3 vb1 vdd well_18 sg13_lv_pmos w=2.22u l=0.84u m=1
RT19 vdd well_19 ntap1 A=4e-12 P=8e-6
MM1_3 net3 vb1 vdd well_19 sg13_lv_pmos w=2.22u l=0.84u m=1
RT20 vdd well_20 ntap1 A=4e-12 P=8e-6
MM1_4 net3 vb1 vdd well_20 sg13_lv_pmos w=2.22u l=0.84u m=1
RT21 vdd well_21 ntap1 A=4e-12 P=8e-6
MM1_5 net3 vb1 vdd well_21 sg13_lv_pmos w=2.22u l=0.84u m=1
RT22 vdd well_22 ntap1 A=4e-12 P=8e-6
MM1_6 net3 vb1 vdd well_22 sg13_lv_pmos w=2.22u l=0.84u m=1
RT23 vdd well_23 ntap1 A=4e-12 P=8e-6
MM1_7 net3 vb1 vdd well_23 sg13_lv_pmos w=2.22u l=0.84u m=1
RT24 vdd well_24 ntap1 A=4e-12 P=8e-6
MM1_8 net3 vb1 vdd well_24 sg13_lv_pmos w=2.22u l=0.84u m=1
RT25 vdd well_25 ntap1 A=4e-12 P=8e-6
MM1_9 net3 vb1 vdd well_25 sg13_lv_pmos w=2.22u l=0.84u m=1
RT26 vdd well_26 ntap1 A=4e-12 P=8e-6
MM1_10 net3 vb1 vdd well_26 sg13_lv_pmos w=2.22u l=0.84u m=1
RT27 vdd well_27 ntap1 A=4e-12 P=8e-6
MM1_11 net3 vb1 vdd well_27 sg13_lv_pmos w=2.22u l=0.84u m=1
RT28 vdd well_28 ntap1 A=4e-12 P=8e-6
MM1_12 net3 vb1 vdd well_28 sg13_lv_pmos w=2.22u l=0.84u m=1
RT29 vdd well_29 ntap1 A=4e-12 P=8e-6
MM1_13 net3 vb1 vdd well_29 sg13_lv_pmos w=2.22u l=0.84u m=1
RT30 vdd well_30 ntap1 A=4e-12 P=8e-6
MM1_14 net3 vb1 vdd well_30 sg13_lv_pmos w=2.22u l=0.84u m=1
RT31 vdd well_31 ntap1 A=4e-12 P=8e-6
MM1_15 net3 vb1 vdd well_31 sg13_lv_pmos w=2.22u l=0.84u m=1
RT32 vdd well_32 ntap1 A=4e-12 P=8e-6
MM10_0 net043 voutp vdd well_32 sg13_lv_pmos w=4.88u l=2.36u m=1
RT33 vdd well_33 ntap1 A=4e-12 P=8e-6
MM10_1 net043 voutp vdd well_33 sg13_lv_pmos w=4.88u l=2.36u m=1
RT34 vdd well_34 ntap1 A=4e-12 P=8e-6
MM10_2 net043 voutp vdd well_34 sg13_lv_pmos w=4.88u l=2.36u m=1
RT35 vdd well_35 ntap1 A=4e-12 P=8e-6
MM10_3 net043 voutp vdd well_35 sg13_lv_pmos w=4.88u l=2.36u m=1
RT36 vdd well_36 ntap1 A=4e-12 P=8e-6
MM10_4 net043 voutp vdd well_36 sg13_lv_pmos w=4.88u l=2.36u m=1
RT37 vdd well_37 ntap1 A=4e-12 P=8e-6
MM10_5 net043 voutp vdd well_37 sg13_lv_pmos w=4.88u l=2.36u m=1
RT38 vdd well_38 ntap1 A=4e-12 P=8e-6
MM10_6 net043 voutp vdd well_38 sg13_lv_pmos w=4.88u l=2.36u m=1
RT39 vdd well_39 ntap1 A=4e-12 P=8e-6
MM10_7 net043 voutp vdd well_39 sg13_lv_pmos w=4.88u l=2.36u m=1
RT40 vdd well_40 ntap1 A=4e-12 P=8e-6
MM10_8 net043 voutp vdd well_40 sg13_lv_pmos w=4.88u l=2.36u m=1
RT41 vdd well_41 ntap1 A=4e-12 P=8e-6
MM10_9 net043 voutp vdd well_41 sg13_lv_pmos w=4.88u l=2.36u m=1
RT42 vdd well_42 ntap1 A=4e-12 P=8e-6
MM10_10 net043 voutp vdd well_42 sg13_lv_pmos w=4.88u l=2.36u m=1
RT43 vdd well_43 ntap1 A=4e-12 P=8e-6
MM10_11 net043 voutp vdd well_43 sg13_lv_pmos w=4.88u l=2.36u m=1
RT44 vdd well_44 ntap1 A=4e-12 P=8e-6
MM10_12 net043 voutp vdd well_44 sg13_lv_pmos w=4.88u l=2.36u m=1
RT45 vdd well_45 ntap1 A=4e-12 P=8e-6
MM10_13 net043 voutp vdd well_45 sg13_lv_pmos w=4.88u l=2.36u m=1
RT46 vdd well_46 ntap1 A=4e-12 P=8e-6
MM10_14 net043 voutp vdd well_46 sg13_lv_pmos w=4.88u l=2.36u m=1
RT47 vdd well_47 ntap1 A=4e-12 P=8e-6
MM10_15 net043 voutp vdd well_47 sg13_lv_pmos w=4.88u l=2.36u m=1
RT48 vdd well_48 ntap1 A=4e-12 P=8e-6
MM10_16 net043 voutp vdd well_48 sg13_lv_pmos w=4.88u l=2.36u m=1
RT49 vdd well_49 ntap1 A=4e-12 P=8e-6
MM10_17 net043 voutp vdd well_49 sg13_lv_pmos w=4.88u l=2.36u m=1
RT50 vdd well_50 ntap1 A=4e-12 P=8e-6
MM10_18 net043 voutp vdd well_50 sg13_lv_pmos w=4.88u l=2.36u m=1
RT51 vdd well_51 ntap1 A=4e-12 P=8e-6
MM10_19 net043 voutp vdd well_51 sg13_lv_pmos w=4.88u l=2.36u m=1
RT52 vdd well_52 ntap1 A=4e-12 P=8e-6
MM10_20 net043 voutp vdd well_52 sg13_lv_pmos w=4.88u l=2.36u m=1
RT53 vdd well_53 ntap1 A=4e-12 P=8e-6
MM10_21 net043 voutp vdd well_53 sg13_lv_pmos w=4.88u l=2.36u m=1
RT54 vdd well_54 ntap1 A=4e-12 P=8e-6
MM10_22 net043 voutp vdd well_54 sg13_lv_pmos w=4.88u l=2.36u m=1
RT55 vdd well_55 ntap1 A=4e-12 P=8e-6
MM10_23 net043 voutp vdd well_55 sg13_lv_pmos w=4.88u l=2.36u m=1
RT56 vdd well_56 ntap1 A=4e-12 P=8e-6
MM11_0 vout voutp vdd well_56 sg13_lv_pmos w=4.46u l=0.98u m=1
RT57 vdd well_57 ntap1 A=4e-12 P=8e-6
MM11_1 vout voutp vdd well_57 sg13_lv_pmos w=4.46u l=0.98u m=1
RT58 vdd well_58 ntap1 A=4e-12 P=8e-6
MM11_2 vout voutp vdd well_58 sg13_lv_pmos w=4.46u l=0.98u m=1
RT59 vdd well_59 ntap1 A=4e-12 P=8e-6
MM11_3 vout voutp vdd well_59 sg13_lv_pmos w=4.46u l=0.98u m=1
RT60 vdd well_60 ntap1 A=4e-12 P=8e-6
MM11_4 vout voutp vdd well_60 sg13_lv_pmos w=4.46u l=0.98u m=1
RT61 vdd well_61 ntap1 A=4e-12 P=8e-6
MM11_5 vout voutp vdd well_61 sg13_lv_pmos w=4.46u l=0.98u m=1
RT62 vdd well_62 ntap1 A=4e-12 P=8e-6
MM11_6 vout voutp vdd well_62 sg13_lv_pmos w=4.46u l=0.98u m=1
RT63 vdd well_63 ntap1 A=4e-12 P=8e-6
MM11_7 vout voutp vdd well_63 sg13_lv_pmos w=4.46u l=0.98u m=1
RT64 vdd well_64 ntap1 A=4e-12 P=8e-6
MM11_8 vout voutp vdd well_64 sg13_lv_pmos w=4.46u l=0.98u m=1
RT65 vss sub ptap1 A=4e-12 P=8e-6
MM12_0 vb4 vb3 net54 sub sg13_lv_nmos w=0.47u l=2.1u m=1
RT66 vss sub ptap1 A=4e-12 P=8e-6
MM12_1 vb4 vb3 net54 sub sg13_lv_nmos w=0.47u l=2.1u m=1
RT67 vss sub ptap1 A=4e-12 P=8e-6
MM12_2 vb4 vb3 net54 sub sg13_lv_nmos w=0.47u l=2.1u m=1
RT68 vss sub ptap1 A=4e-12 P=8e-6
MM12_3 vb4 vb3 net54 sub sg13_lv_nmos w=0.47u l=2.1u m=1
RT69 vss sub ptap1 A=4e-12 P=8e-6
MM12_4 vb4 vb3 net54 sub sg13_lv_nmos w=0.47u l=2.1u m=1
RT70 vss sub ptap1 A=4e-12 P=8e-6
MM12_5 vb4 vb3 net54 sub sg13_lv_nmos w=0.47u l=2.1u m=1
RT71 vss sub ptap1 A=4e-12 P=8e-6
MM12_6 vb4 vb3 net54 sub sg13_lv_nmos w=0.47u l=2.1u m=1
RT72 vss sub ptap1 A=4e-12 P=8e-6
MM12_7 vb4 vb3 net54 sub sg13_lv_nmos w=0.47u l=2.1u m=1
RT73 vss sub ptap1 A=4e-12 P=8e-6
MM13_0 net7 vb3 net56 sub sg13_lv_nmos w=0.47u l=2.1u m=1
RT74 vss sub ptap1 A=4e-12 P=8e-6
MM13_1 net7 vb3 net56 sub sg13_lv_nmos w=0.47u l=2.1u m=1
RT75 vss sub ptap1 A=4e-12 P=8e-6
MM13_2 net7 vb3 net56 sub sg13_lv_nmos w=0.47u l=2.1u m=1
RT76 vss sub ptap1 A=4e-12 P=8e-6
MM13_3 net7 vb3 net56 sub sg13_lv_nmos w=0.47u l=2.1u m=1
RT77 vss sub ptap1 A=4e-12 P=8e-6
MM13_4 net7 vb3 net56 sub sg13_lv_nmos w=0.47u l=2.1u m=1
RT78 vss sub ptap1 A=4e-12 P=8e-6
MM13_5 net7 vb3 net56 sub sg13_lv_nmos w=0.47u l=2.1u m=1
RT79 vss sub ptap1 A=4e-12 P=8e-6
MM13_6 net7 vb3 net56 sub sg13_lv_nmos w=0.47u l=2.1u m=1
RT80 vss sub ptap1 A=4e-12 P=8e-6
MM13_7 net7 vb3 net56 sub sg13_lv_nmos w=0.47u l=2.1u m=1
RT81 vss sub ptap1 A=4e-12 P=8e-6
MM14_0 vb3 vb3 vss sub sg13_lv_nmos w=0.47u l=2.1u m=1
RT82 vss sub ptap1 A=4e-12 P=8e-6
MM14_1 vb3 vb3 vss sub sg13_lv_nmos w=0.47u l=2.1u m=1
RT83 vss sub ptap1 A=4e-12 P=8e-6
MM15_0 voutn vb3 dm_2 sub sg13_lv_nmos w=0.47u l=2.1u m=1
RT84 vss sub ptap1 A=4e-12 P=8e-6
MM15_1 voutn vb3 dm_2 sub sg13_lv_nmos w=0.47u l=2.1u m=1
RT85 vss sub ptap1 A=4e-12 P=8e-6
MM15_2 voutn vb3 dm_2 sub sg13_lv_nmos w=0.47u l=2.1u m=1
RT86 vss sub ptap1 A=4e-12 P=8e-6
MM15_3 voutn vb3 dm_2 sub sg13_lv_nmos w=0.47u l=2.1u m=1
RT87 vss sub ptap1 A=4e-12 P=8e-6
MM15_4 voutn vb3 dm_2 sub sg13_lv_nmos w=0.47u l=2.1u m=1
RT88 vss sub ptap1 A=4e-12 P=8e-6
MM15_5 voutn vb3 dm_2 sub sg13_lv_nmos w=0.47u l=2.1u m=1
RT89 vss sub ptap1 A=4e-12 P=8e-6
MM15_6 voutn vb3 dm_2 sub sg13_lv_nmos w=0.47u l=2.1u m=1
RT90 vss sub ptap1 A=4e-12 P=8e-6
MM15_7 voutn vb3 dm_2 sub sg13_lv_nmos w=0.47u l=2.1u m=1
RT91 vss sub ptap1 A=4e-12 P=8e-6
MM15_8 voutn vb3 dm_2 sub sg13_lv_nmos w=0.47u l=2.1u m=1
RT92 vss sub ptap1 A=4e-12 P=8e-6
MM15_9 voutn vb3 dm_2 sub sg13_lv_nmos w=0.47u l=2.1u m=1
RT93 vss sub ptap1 A=4e-12 P=8e-6
MM15_10 voutn vb3 dm_2 sub sg13_lv_nmos w=0.47u l=2.1u m=1
RT94 vss sub ptap1 A=4e-12 P=8e-6
MM15_11 voutn vb3 dm_2 sub sg13_lv_nmos w=0.47u l=2.1u m=1
RT95 vss sub ptap1 A=4e-12 P=8e-6
MM15_12 voutn vb3 dm_2 sub sg13_lv_nmos w=0.47u l=2.1u m=1
RT96 vss sub ptap1 A=4e-12 P=8e-6
MM15_13 voutn vb3 dm_2 sub sg13_lv_nmos w=0.47u l=2.1u m=1
RT97 vss sub ptap1 A=4e-12 P=8e-6
MM15_14 voutn vb3 dm_2 sub sg13_lv_nmos w=0.47u l=2.1u m=1
RT98 vss sub ptap1 A=4e-12 P=8e-6
MM15_15 voutn vb3 dm_2 sub sg13_lv_nmos w=0.47u l=2.1u m=1
RT99 vss sub ptap1 A=4e-12 P=8e-6
MM16_0 voutp vb3 net063 sub sg13_lv_nmos w=0.47u l=2.1u m=1
RT100 vss sub ptap1 A=4e-12 P=8e-6
MM16_1 voutp vb3 net063 sub sg13_lv_nmos w=0.47u l=2.1u m=1
RT101 vss sub ptap1 A=4e-12 P=8e-6
MM16_2 voutp vb3 net063 sub sg13_lv_nmos w=0.47u l=2.1u m=1
RT102 vss sub ptap1 A=4e-12 P=8e-6
MM16_3 voutp vb3 net063 sub sg13_lv_nmos w=0.47u l=2.1u m=1
RT103 vss sub ptap1 A=4e-12 P=8e-6
MM16_4 voutp vb3 net063 sub sg13_lv_nmos w=0.47u l=2.1u m=1
RT104 vss sub ptap1 A=4e-12 P=8e-6
MM16_5 voutp vb3 net063 sub sg13_lv_nmos w=0.47u l=2.1u m=1
RT105 vss sub ptap1 A=4e-12 P=8e-6
MM16_6 voutp vb3 net063 sub sg13_lv_nmos w=0.47u l=2.1u m=1
RT106 vss sub ptap1 A=4e-12 P=8e-6
MM16_7 voutp vb3 net063 sub sg13_lv_nmos w=0.47u l=2.1u m=1
RT107 vss sub ptap1 A=4e-12 P=8e-6
MM16_8 voutp vb3 net063 sub sg13_lv_nmos w=0.47u l=2.1u m=1
RT108 vss sub ptap1 A=4e-12 P=8e-6
MM16_9 voutp vb3 net063 sub sg13_lv_nmos w=0.47u l=2.1u m=1
RT109 vss sub ptap1 A=4e-12 P=8e-6
MM16_10 voutp vb3 net063 sub sg13_lv_nmos w=0.47u l=2.1u m=1
RT110 vss sub ptap1 A=4e-12 P=8e-6
MM16_11 voutp vb3 net063 sub sg13_lv_nmos w=0.47u l=2.1u m=1
RT111 vss sub ptap1 A=4e-12 P=8e-6
MM16_12 voutp vb3 net063 sub sg13_lv_nmos w=0.47u l=2.1u m=1
RT112 vss sub ptap1 A=4e-12 P=8e-6
MM16_13 voutp vb3 net063 sub sg13_lv_nmos w=0.47u l=2.1u m=1
RT113 vss sub ptap1 A=4e-12 P=8e-6
MM16_14 voutp vb3 net063 sub sg13_lv_nmos w=0.47u l=2.1u m=1
RT114 vss sub ptap1 A=4e-12 P=8e-6
MM16_15 voutp vb3 net063 sub sg13_lv_nmos w=0.47u l=2.1u m=1
RT115 vss sub ptap1 A=4e-12 P=8e-6
MM17_0 net54 vb4 vss sub sg13_lv_nmos w=0.47u l=2.1u m=1
RT116 vss sub ptap1 A=4e-12 P=8e-6
MM17_1 net54 vb4 vss sub sg13_lv_nmos w=0.47u l=2.1u m=1
RT117 vss sub ptap1 A=4e-12 P=8e-6
MM17_2 net54 vb4 vss sub sg13_lv_nmos w=0.47u l=2.1u m=1
RT118 vss sub ptap1 A=4e-12 P=8e-6
MM17_3 net54 vb4 vss sub sg13_lv_nmos w=0.47u l=2.1u m=1
RT119 vss sub ptap1 A=4e-12 P=8e-6
MM17_4 net54 vb4 vss sub sg13_lv_nmos w=0.47u l=2.1u m=1
RT120 vss sub ptap1 A=4e-12 P=8e-6
MM17_5 net54 vb4 vss sub sg13_lv_nmos w=0.47u l=2.1u m=1
RT121 vss sub ptap1 A=4e-12 P=8e-6
MM17_6 net54 vb4 vss sub sg13_lv_nmos w=0.47u l=2.1u m=1
RT122 vss sub ptap1 A=4e-12 P=8e-6
MM17_7 net54 vb4 vss sub sg13_lv_nmos w=0.47u l=2.1u m=1
RT123 vss sub ptap1 A=4e-12 P=8e-6
MM18_0 net56 vb4 vss sub sg13_lv_nmos w=0.47u l=2.1u m=1
RT124 vss sub ptap1 A=4e-12 P=8e-6
MM18_1 net56 vb4 vss sub sg13_lv_nmos w=0.47u l=2.1u m=1
RT125 vss sub ptap1 A=4e-12 P=8e-6
MM18_2 net56 vb4 vss sub sg13_lv_nmos w=0.47u l=2.1u m=1
RT126 vss sub ptap1 A=4e-12 P=8e-6
MM18_3 net56 vb4 vss sub sg13_lv_nmos w=0.47u l=2.1u m=1
RT127 vss sub ptap1 A=4e-12 P=8e-6
MM18_4 net56 vb4 vss sub sg13_lv_nmos w=0.47u l=2.1u m=1
RT128 vss sub ptap1 A=4e-12 P=8e-6
MM18_5 net56 vb4 vss sub sg13_lv_nmos w=0.47u l=2.1u m=1
RT129 vss sub ptap1 A=4e-12 P=8e-6
MM18_6 net56 vb4 vss sub sg13_lv_nmos w=0.47u l=2.1u m=1
RT130 vss sub ptap1 A=4e-12 P=8e-6
MM18_7 net56 vb4 vss sub sg13_lv_nmos w=0.47u l=2.1u m=1
RT131 vss sub ptap1 A=4e-12 P=8e-6
MM19_0 dm_2 vb4 vss sub sg13_lv_nmos w=0.47u l=2.1u m=1
RT132 vss sub ptap1 A=4e-12 P=8e-6
MM19_1 dm_2 vb4 vss sub sg13_lv_nmos w=0.47u l=2.1u m=1
RT133 vss sub ptap1 A=4e-12 P=8e-6
MM19_2 dm_2 vb4 vss sub sg13_lv_nmos w=0.47u l=2.1u m=1
RT134 vss sub ptap1 A=4e-12 P=8e-6
MM19_3 dm_2 vb4 vss sub sg13_lv_nmos w=0.47u l=2.1u m=1
RT135 vss sub ptap1 A=4e-12 P=8e-6
MM19_4 dm_2 vb4 vss sub sg13_lv_nmos w=0.47u l=2.1u m=1
RT136 vss sub ptap1 A=4e-12 P=8e-6
MM19_5 dm_2 vb4 vss sub sg13_lv_nmos w=0.47u l=2.1u m=1
RT137 vss sub ptap1 A=4e-12 P=8e-6
MM19_6 dm_2 vb4 vss sub sg13_lv_nmos w=0.47u l=2.1u m=1
RT138 vss sub ptap1 A=4e-12 P=8e-6
MM19_7 dm_2 vb4 vss sub sg13_lv_nmos w=0.47u l=2.1u m=1
RT139 vss sub ptap1 A=4e-12 P=8e-6
MM19_8 dm_2 vb4 vss sub sg13_lv_nmos w=0.47u l=2.1u m=1
RT140 vss sub ptap1 A=4e-12 P=8e-6
MM19_9 dm_2 vb4 vss sub sg13_lv_nmos w=0.47u l=2.1u m=1
RT141 vss sub ptap1 A=4e-12 P=8e-6
MM19_10 dm_2 vb4 vss sub sg13_lv_nmos w=0.47u l=2.1u m=1
RT142 vss sub ptap1 A=4e-12 P=8e-6
MM19_11 dm_2 vb4 vss sub sg13_lv_nmos w=0.47u l=2.1u m=1
RT143 vss sub ptap1 A=4e-12 P=8e-6
MM19_12 dm_2 vb4 vss sub sg13_lv_nmos w=0.47u l=2.1u m=1
RT144 vss sub ptap1 A=4e-12 P=8e-6
MM19_13 dm_2 vb4 vss sub sg13_lv_nmos w=0.47u l=2.1u m=1
RT145 vss sub ptap1 A=4e-12 P=8e-6
MM19_14 dm_2 vb4 vss sub sg13_lv_nmos w=0.47u l=2.1u m=1
RT146 vss sub ptap1 A=4e-12 P=8e-6
MM19_15 dm_2 vb4 vss sub sg13_lv_nmos w=0.47u l=2.1u m=1
RT147 vdd well_147 ntap1 A=4e-12 P=8e-6
MM2_0 net6 vb1 vdd well_147 sg13_lv_pmos w=2.22u l=0.84u m=1
RT148 vdd well_148 ntap1 A=4e-12 P=8e-6
MM2_1 net6 vb1 vdd well_148 sg13_lv_pmos w=2.22u l=0.84u m=1
RT149 vdd well_149 ntap1 A=4e-12 P=8e-6
MM2_2 net6 vb1 vdd well_149 sg13_lv_pmos w=2.22u l=0.84u m=1
RT150 vdd well_150 ntap1 A=4e-12 P=8e-6
MM2_3 net6 vb1 vdd well_150 sg13_lv_pmos w=2.22u l=0.84u m=1
RT151 vdd well_151 ntap1 A=4e-12 P=8e-6
MM2_4 net6 vb1 vdd well_151 sg13_lv_pmos w=2.22u l=0.84u m=1
RT152 vdd well_152 ntap1 A=4e-12 P=8e-6
MM2_5 net6 vb1 vdd well_152 sg13_lv_pmos w=2.22u l=0.84u m=1
RT153 vdd well_153 ntap1 A=4e-12 P=8e-6
MM2_6 net6 vb1 vdd well_153 sg13_lv_pmos w=2.22u l=0.84u m=1
RT154 vdd well_154 ntap1 A=4e-12 P=8e-6
MM2_7 net6 vb1 vdd well_154 sg13_lv_pmos w=2.22u l=0.84u m=1
RT155 vdd well_155 ntap1 A=4e-12 P=8e-6
MM2_8 net6 vb1 vdd well_155 sg13_lv_pmos w=2.22u l=0.84u m=1
RT156 vdd well_156 ntap1 A=4e-12 P=8e-6
MM2_9 net6 vb1 vdd well_156 sg13_lv_pmos w=2.22u l=0.84u m=1
RT157 vdd well_157 ntap1 A=4e-12 P=8e-6
MM2_10 net6 vb1 vdd well_157 sg13_lv_pmos w=2.22u l=0.84u m=1
RT158 vdd well_158 ntap1 A=4e-12 P=8e-6
MM2_11 net6 vb1 vdd well_158 sg13_lv_pmos w=2.22u l=0.84u m=1
RT159 vdd well_159 ntap1 A=4e-12 P=8e-6
MM2_12 net6 vb1 vdd well_159 sg13_lv_pmos w=2.22u l=0.84u m=1
RT160 vdd well_160 ntap1 A=4e-12 P=8e-6
MM2_13 net6 vb1 vdd well_160 sg13_lv_pmos w=2.22u l=0.84u m=1
RT161 vdd well_161 ntap1 A=4e-12 P=8e-6
MM2_14 net6 vb1 vdd well_161 sg13_lv_pmos w=2.22u l=0.84u m=1
RT162 vdd well_162 ntap1 A=4e-12 P=8e-6
MM2_15 net6 vb1 vdd well_162 sg13_lv_pmos w=2.22u l=0.84u m=1
RT163 vss sub ptap1 A=4e-12 P=8e-6
MM20_0 net063 vb4 vss sub sg13_lv_nmos w=0.47u l=2.1u m=1
RT164 vss sub ptap1 A=4e-12 P=8e-6
MM20_1 net063 vb4 vss sub sg13_lv_nmos w=0.47u l=2.1u m=1
RT165 vss sub ptap1 A=4e-12 P=8e-6
MM20_2 net063 vb4 vss sub sg13_lv_nmos w=0.47u l=2.1u m=1
RT166 vss sub ptap1 A=4e-12 P=8e-6
MM20_3 net063 vb4 vss sub sg13_lv_nmos w=0.47u l=2.1u m=1
RT167 vss sub ptap1 A=4e-12 P=8e-6
MM20_4 net063 vb4 vss sub sg13_lv_nmos w=0.47u l=2.1u m=1
RT168 vss sub ptap1 A=4e-12 P=8e-6
MM20_5 net063 vb4 vss sub sg13_lv_nmos w=0.47u l=2.1u m=1
RT169 vss sub ptap1 A=4e-12 P=8e-6
MM20_6 net063 vb4 vss sub sg13_lv_nmos w=0.47u l=2.1u m=1
RT170 vss sub ptap1 A=4e-12 P=8e-6
MM20_7 net063 vb4 vss sub sg13_lv_nmos w=0.47u l=2.1u m=1
RT171 vss sub ptap1 A=4e-12 P=8e-6
MM20_8 net063 vb4 vss sub sg13_lv_nmos w=0.47u l=2.1u m=1
RT172 vss sub ptap1 A=4e-12 P=8e-6
MM20_9 net063 vb4 vss sub sg13_lv_nmos w=0.47u l=2.1u m=1
RT173 vss sub ptap1 A=4e-12 P=8e-6
MM20_10 net063 vb4 vss sub sg13_lv_nmos w=0.47u l=2.1u m=1
RT174 vss sub ptap1 A=4e-12 P=8e-6
MM20_11 net063 vb4 vss sub sg13_lv_nmos w=0.47u l=2.1u m=1
RT175 vss sub ptap1 A=4e-12 P=8e-6
MM20_12 net063 vb4 vss sub sg13_lv_nmos w=0.47u l=2.1u m=1
RT176 vss sub ptap1 A=4e-12 P=8e-6
MM20_13 net063 vb4 vss sub sg13_lv_nmos w=0.47u l=2.1u m=1
RT177 vss sub ptap1 A=4e-12 P=8e-6
MM20_14 net063 vb4 vss sub sg13_lv_nmos w=0.47u l=2.1u m=1
RT178 vss sub ptap1 A=4e-12 P=8e-6
MM20_15 net063 vb4 vss sub sg13_lv_nmos w=0.47u l=2.1u m=1
RT179 vss sub ptap1 A=4e-12 P=8e-6
MM23_0 vout net10 vss sub sg13_lv_nmos w=9.59u l=0.51u m=1
RT180 vss sub ptap1 A=4e-12 P=8e-6
MM23_1 vout net10 vss sub sg13_lv_nmos w=9.59u l=0.51u m=1
RT181 vss sub ptap1 A=4e-12 P=8e-6
MM23_2 vout net10 vss sub sg13_lv_nmos w=9.59u l=0.51u m=1
RT182 vdd well_182 ntap1 A=4e-12 P=8e-6
MM3_0 net8 vb1 vdd well_182 sg13_lv_pmos w=2.22u l=0.84u m=1
RT183 vdd well_183 ntap1 A=4e-12 P=8e-6
MM3_1 net8 vb1 vdd well_183 sg13_lv_pmos w=2.22u l=0.84u m=1
RT184 vdd well_184 ntap1 A=4e-12 P=8e-6
MM3_2 net8 vb1 vdd well_184 sg13_lv_pmos w=2.22u l=0.84u m=1
RT185 vdd well_185 ntap1 A=4e-12 P=8e-6
MM3_3 net8 vb1 vdd well_185 sg13_lv_pmos w=2.22u l=0.84u m=1
RT186 vdd well_186 ntap1 A=4e-12 P=8e-6
MM3_4 net8 vb1 vdd well_186 sg13_lv_pmos w=2.22u l=0.84u m=1
RT187 vdd well_187 ntap1 A=4e-12 P=8e-6
MM3_5 net8 vb1 vdd well_187 sg13_lv_pmos w=2.22u l=0.84u m=1
RT188 vdd well_188 ntap1 A=4e-12 P=8e-6
MM3_6 net8 vb1 vdd well_188 sg13_lv_pmos w=2.22u l=0.84u m=1
RT189 vdd well_189 ntap1 A=4e-12 P=8e-6
MM3_7 net8 vb1 vdd well_189 sg13_lv_pmos w=2.22u l=0.84u m=1
RT190 vdd well_190 ntap1 A=4e-12 P=8e-6
MM3_8 net8 vb1 vdd well_190 sg13_lv_pmos w=2.22u l=0.84u m=1
RT191 vdd well_191 ntap1 A=4e-12 P=8e-6
MM3_9 net8 vb1 vdd well_191 sg13_lv_pmos w=2.22u l=0.84u m=1
RT192 vdd well_192 ntap1 A=4e-12 P=8e-6
MM3_10 net8 vb1 vdd well_192 sg13_lv_pmos w=2.22u l=0.84u m=1
RT193 vdd well_193 ntap1 A=4e-12 P=8e-6
MM3_11 net8 vb1 vdd well_193 sg13_lv_pmos w=2.22u l=0.84u m=1
RT194 vdd well_194 ntap1 A=4e-12 P=8e-6
MM3_12 net8 vb1 vdd well_194 sg13_lv_pmos w=2.22u l=0.84u m=1
RT195 vdd well_195 ntap1 A=4e-12 P=8e-6
MM3_13 net8 vb1 vdd well_195 sg13_lv_pmos w=2.22u l=0.84u m=1
RT196 vdd well_196 ntap1 A=4e-12 P=8e-6
MM3_14 net8 vb1 vdd well_196 sg13_lv_pmos w=2.22u l=0.84u m=1
RT197 vdd well_197 ntap1 A=4e-12 P=8e-6
MM3_15 net8 vb1 vdd well_197 sg13_lv_pmos w=2.22u l=0.84u m=1
RT198 vdd well_198 ntap1 A=4e-12 P=8e-6
MM4_0 net31 vb1 vdd well_198 sg13_lv_pmos w=2.22u l=0.84u m=1
RT199 vdd well_199 ntap1 A=4e-12 P=8e-6
MM4_1 net31 vb1 vdd well_199 sg13_lv_pmos w=2.22u l=0.84u m=1
RT200 vdd well_200 ntap1 A=4e-12 P=8e-6
MM4_2 net31 vb1 vdd well_200 sg13_lv_pmos w=2.22u l=0.84u m=1
RT201 vdd well_201 ntap1 A=4e-12 P=8e-6
MM4_3 net31 vb1 vdd well_201 sg13_lv_pmos w=2.22u l=0.84u m=1
RT202 vdd well_202 ntap1 A=4e-12 P=8e-6
MM4_4 net31 vb1 vdd well_202 sg13_lv_pmos w=2.22u l=0.84u m=1
RT203 vdd well_203 ntap1 A=4e-12 P=8e-6
MM4_5 net31 vb1 vdd well_203 sg13_lv_pmos w=2.22u l=0.84u m=1
RT204 vdd well_204 ntap1 A=4e-12 P=8e-6
MM4_6 net31 vb1 vdd well_204 sg13_lv_pmos w=2.22u l=0.84u m=1
RT205 vdd well_205 ntap1 A=4e-12 P=8e-6
MM4_7 net31 vb1 vdd well_205 sg13_lv_pmos w=2.22u l=0.84u m=1
RT206 vdd well_206 ntap1 A=4e-12 P=8e-6
MM4_8 net31 vb1 vdd well_206 sg13_lv_pmos w=2.22u l=0.84u m=1
RT207 vdd well_207 ntap1 A=4e-12 P=8e-6
MM4_9 net31 vb1 vdd well_207 sg13_lv_pmos w=2.22u l=0.84u m=1
RT208 vdd well_208 ntap1 A=4e-12 P=8e-6
MM4_10 net31 vb1 vdd well_208 sg13_lv_pmos w=2.22u l=0.84u m=1
RT209 vdd well_209 ntap1 A=4e-12 P=8e-6
MM4_11 net31 vb1 vdd well_209 sg13_lv_pmos w=2.22u l=0.84u m=1
RT210 vdd well_210 ntap1 A=4e-12 P=8e-6
MM4_12 net31 vb1 vdd well_210 sg13_lv_pmos w=2.22u l=0.84u m=1
RT211 vdd well_211 ntap1 A=4e-12 P=8e-6
MM4_13 net31 vb1 vdd well_211 sg13_lv_pmos w=2.22u l=0.84u m=1
RT212 vdd well_212 ntap1 A=4e-12 P=8e-6
MM4_14 net31 vb1 vdd well_212 sg13_lv_pmos w=2.22u l=0.84u m=1
RT213 vdd well_213 ntap1 A=4e-12 P=8e-6
MM4_15 net31 vb1 vdd well_213 sg13_lv_pmos w=2.22u l=0.84u m=1
RT214 vdd well_214 ntap1 A=4e-12 P=8e-6
MM4_16 net31 vb1 vdd well_214 sg13_lv_pmos w=2.22u l=0.84u m=1
RT215 vdd well_215 ntap1 A=4e-12 P=8e-6
MM4_17 net31 vb1 vdd well_215 sg13_lv_pmos w=2.22u l=0.84u m=1
RT216 vdd well_216 ntap1 A=4e-12 P=8e-6
MM4_18 net31 vb1 vdd well_216 sg13_lv_pmos w=2.22u l=0.84u m=1
RT217 vdd well_217 ntap1 A=4e-12 P=8e-6
MM4_19 net31 vb1 vdd well_217 sg13_lv_pmos w=2.22u l=0.84u m=1
RT218 vdd well_218 ntap1 A=4e-12 P=8e-6
MM4_20 net31 vb1 vdd well_218 sg13_lv_pmos w=2.22u l=0.84u m=1
RT219 vdd well_219 ntap1 A=4e-12 P=8e-6
MM4_21 net31 vb1 vdd well_219 sg13_lv_pmos w=2.22u l=0.84u m=1
RT220 vdd well_220 ntap1 A=4e-12 P=8e-6
MM4_22 net31 vb1 vdd well_220 sg13_lv_pmos w=2.22u l=0.84u m=1
RT221 vdd well_221 ntap1 A=4e-12 P=8e-6
MM4_23 net31 vb1 vdd well_221 sg13_lv_pmos w=2.22u l=0.84u m=1
RT222 vdd well_222 ntap1 A=4e-12 P=8e-6
MM4_24 net31 vb1 vdd well_222 sg13_lv_pmos w=2.22u l=0.84u m=1
RT223 vdd well_223 ntap1 A=4e-12 P=8e-6
MM4_25 net31 vb1 vdd well_223 sg13_lv_pmos w=2.22u l=0.84u m=1
RT224 vdd well_224 ntap1 A=4e-12 P=8e-6
MM4_26 net31 vb1 vdd well_224 sg13_lv_pmos w=2.22u l=0.84u m=1
RT225 vdd well_225 ntap1 A=4e-12 P=8e-6
MM4_27 net31 vb1 vdd well_225 sg13_lv_pmos w=2.22u l=0.84u m=1
RT226 vdd well_226 ntap1 A=4e-12 P=8e-6
MM4_28 net31 vb1 vdd well_226 sg13_lv_pmos w=2.22u l=0.84u m=1
RT227 vdd well_227 ntap1 A=4e-12 P=8e-6
MM4_29 net31 vb1 vdd well_227 sg13_lv_pmos w=2.22u l=0.84u m=1
RT228 vdd well_228 ntap1 A=4e-12 P=8e-6
MM4_30 net31 vb1 vdd well_228 sg13_lv_pmos w=2.22u l=0.84u m=1
RT229 vdd well_229 ntap1 A=4e-12 P=8e-6
MM4_31 net31 vb1 vdd well_229 sg13_lv_pmos w=2.22u l=0.84u m=1
RT230 vdd well_230 ntap1 A=4e-12 P=8e-6
MM5_0 voutn voutn vdd well_230 sg13_lv_pmos w=2.22u l=0.84u m=1
RT231 vdd well_231 ntap1 A=4e-12 P=8e-6
MM5_1 voutn voutn vdd well_231 sg13_lv_pmos w=2.22u l=0.84u m=1
RT232 vdd well_232 ntap1 A=4e-12 P=8e-6
MM5_2 voutn voutn vdd well_232 sg13_lv_pmos w=2.22u l=0.84u m=1
RT233 vdd well_233 ntap1 A=4e-12 P=8e-6
MM5_3 voutn voutn vdd well_233 sg13_lv_pmos w=2.22u l=0.84u m=1
RT234 vdd well_234 ntap1 A=4e-12 P=8e-6
MM5_4 voutn voutn vdd well_234 sg13_lv_pmos w=2.22u l=0.84u m=1
RT235 vdd well_235 ntap1 A=4e-12 P=8e-6
MM5_5 voutn voutn vdd well_235 sg13_lv_pmos w=2.22u l=0.84u m=1
RT236 vdd well_236 ntap1 A=4e-12 P=8e-6
MM5_6 voutn voutn vdd well_236 sg13_lv_pmos w=2.22u l=0.84u m=1
RT237 vdd well_237 ntap1 A=4e-12 P=8e-6
MM5_7 voutn voutn vdd well_237 sg13_lv_pmos w=2.22u l=0.84u m=1
RT238 vdd well_238 ntap1 A=4e-12 P=8e-6
MM5_8 voutn voutn vdd well_238 sg13_lv_pmos w=2.22u l=0.84u m=1
RT239 vdd well_239 ntap1 A=4e-12 P=8e-6
MM5_9 voutn voutn vdd well_239 sg13_lv_pmos w=2.22u l=0.84u m=1
RT240 vdd well_240 ntap1 A=4e-12 P=8e-6
MM5_10 voutn voutn vdd well_240 sg13_lv_pmos w=2.22u l=0.84u m=1
RT241 vdd well_241 ntap1 A=4e-12 P=8e-6
MM5_11 voutn voutn vdd well_241 sg13_lv_pmos w=2.22u l=0.84u m=1
RT242 vdd well_242 ntap1 A=4e-12 P=8e-6
MM5_12 voutn voutn vdd well_242 sg13_lv_pmos w=2.22u l=0.84u m=1
RT243 vdd well_243 ntap1 A=4e-12 P=8e-6
MM5_13 voutn voutn vdd well_243 sg13_lv_pmos w=2.22u l=0.84u m=1
RT244 vdd well_244 ntap1 A=4e-12 P=8e-6
MM5_14 voutn voutn vdd well_244 sg13_lv_pmos w=2.22u l=0.84u m=1
RT245 vdd well_245 ntap1 A=4e-12 P=8e-6
MM5_15 voutn voutn vdd well_245 sg13_lv_pmos w=2.22u l=0.84u m=1
RT246 vdd well_246 ntap1 A=4e-12 P=8e-6
MM57_0 vb1 vb2 net2 well_246 sg13_lv_pmos w=2.22u l=0.84u m=1
RT247 vdd well_247 ntap1 A=4e-12 P=8e-6
MM57_1 vb1 vb2 net2 well_247 sg13_lv_pmos w=2.22u l=0.84u m=1
RT248 vdd well_248 ntap1 A=4e-12 P=8e-6
MM57_2 vb1 vb2 net2 well_248 sg13_lv_pmos w=2.22u l=0.84u m=1
RT249 vdd well_249 ntap1 A=4e-12 P=8e-6
MM57_3 vb1 vb2 net2 well_249 sg13_lv_pmos w=2.22u l=0.84u m=1
RT250 vdd well_250 ntap1 A=4e-12 P=8e-6
MM57_4 vb1 vb2 net2 well_250 sg13_lv_pmos w=2.22u l=0.84u m=1
RT251 vdd well_251 ntap1 A=4e-12 P=8e-6
MM57_5 vb1 vb2 net2 well_251 sg13_lv_pmos w=2.22u l=0.84u m=1
RT252 vdd well_252 ntap1 A=4e-12 P=8e-6
MM57_6 vb1 vb2 net2 well_252 sg13_lv_pmos w=2.22u l=0.84u m=1
RT253 vdd well_253 ntap1 A=4e-12 P=8e-6
MM57_7 vb1 vb2 net2 well_253 sg13_lv_pmos w=2.22u l=0.84u m=1
RT254 vdd well_254 ntap1 A=4e-12 P=8e-6
MM57_8 vb1 vb2 net2 well_254 sg13_lv_pmos w=2.22u l=0.84u m=1
RT255 vdd well_255 ntap1 A=4e-12 P=8e-6
MM57_9 vb1 vb2 net2 well_255 sg13_lv_pmos w=2.22u l=0.84u m=1
RT256 vdd well_256 ntap1 A=4e-12 P=8e-6
MM57_10 vb1 vb2 net2 well_256 sg13_lv_pmos w=2.22u l=0.84u m=1
RT257 vdd well_257 ntap1 A=4e-12 P=8e-6
MM57_11 vb1 vb2 net2 well_257 sg13_lv_pmos w=2.22u l=0.84u m=1
RT258 vdd well_258 ntap1 A=4e-12 P=8e-6
MM57_12 vb1 vb2 net2 well_258 sg13_lv_pmos w=2.22u l=0.84u m=1
RT259 vdd well_259 ntap1 A=4e-12 P=8e-6
MM57_13 vb1 vb2 net2 well_259 sg13_lv_pmos w=2.22u l=0.84u m=1
RT260 vdd well_260 ntap1 A=4e-12 P=8e-6
MM57_14 vb1 vb2 net2 well_260 sg13_lv_pmos w=2.22u l=0.84u m=1
RT261 vdd well_261 ntap1 A=4e-12 P=8e-6
MM57_15 vb1 vb2 net2 well_261 sg13_lv_pmos w=2.22u l=0.84u m=1
RT262 vdd well_262 ntap1 A=4e-12 P=8e-6
MM58_0 vb4 vb2 net3 well_262 sg13_lv_pmos w=2.22u l=0.84u m=1
RT263 vdd well_263 ntap1 A=4e-12 P=8e-6
MM58_1 vb4 vb2 net3 well_263 sg13_lv_pmos w=2.22u l=0.84u m=1
RT264 vdd well_264 ntap1 A=4e-12 P=8e-6
MM58_2 vb4 vb2 net3 well_264 sg13_lv_pmos w=2.22u l=0.84u m=1
RT265 vdd well_265 ntap1 A=4e-12 P=8e-6
MM58_3 vb4 vb2 net3 well_265 sg13_lv_pmos w=2.22u l=0.84u m=1
RT266 vdd well_266 ntap1 A=4e-12 P=8e-6
MM58_4 vb4 vb2 net3 well_266 sg13_lv_pmos w=2.22u l=0.84u m=1
RT267 vdd well_267 ntap1 A=4e-12 P=8e-6
MM58_5 vb4 vb2 net3 well_267 sg13_lv_pmos w=2.22u l=0.84u m=1
RT268 vdd well_268 ntap1 A=4e-12 P=8e-6
MM58_6 vb4 vb2 net3 well_268 sg13_lv_pmos w=2.22u l=0.84u m=1
RT269 vdd well_269 ntap1 A=4e-12 P=8e-6
MM58_7 vb4 vb2 net3 well_269 sg13_lv_pmos w=2.22u l=0.84u m=1
RT270 vdd well_270 ntap1 A=4e-12 P=8e-6
MM58_8 vb4 vb2 net3 well_270 sg13_lv_pmos w=2.22u l=0.84u m=1
RT271 vdd well_271 ntap1 A=4e-12 P=8e-6
MM58_9 vb4 vb2 net3 well_271 sg13_lv_pmos w=2.22u l=0.84u m=1
RT272 vdd well_272 ntap1 A=4e-12 P=8e-6
MM58_10 vb4 vb2 net3 well_272 sg13_lv_pmos w=2.22u l=0.84u m=1
RT273 vdd well_273 ntap1 A=4e-12 P=8e-6
MM58_11 vb4 vb2 net3 well_273 sg13_lv_pmos w=2.22u l=0.84u m=1
RT274 vdd well_274 ntap1 A=4e-12 P=8e-6
MM58_12 vb4 vb2 net3 well_274 sg13_lv_pmos w=2.22u l=0.84u m=1
RT275 vdd well_275 ntap1 A=4e-12 P=8e-6
MM58_13 vb4 vb2 net3 well_275 sg13_lv_pmos w=2.22u l=0.84u m=1
RT276 vdd well_276 ntap1 A=4e-12 P=8e-6
MM58_14 vb4 vb2 net3 well_276 sg13_lv_pmos w=2.22u l=0.84u m=1
RT277 vdd well_277 ntap1 A=4e-12 P=8e-6
MM58_15 vb4 vb2 net3 well_277 sg13_lv_pmos w=2.22u l=0.84u m=1
RT278 vdd well_278 ntap1 A=4e-12 P=8e-6
MM6_0 voutp voutn vdd well_278 sg13_lv_pmos w=2.22u l=0.84u m=1
RT279 vdd well_279 ntap1 A=4e-12 P=8e-6
MM6_1 voutp voutn vdd well_279 sg13_lv_pmos w=2.22u l=0.84u m=1
RT280 vdd well_280 ntap1 A=4e-12 P=8e-6
MM6_2 voutp voutn vdd well_280 sg13_lv_pmos w=2.22u l=0.84u m=1
RT281 vdd well_281 ntap1 A=4e-12 P=8e-6
MM6_3 voutp voutn vdd well_281 sg13_lv_pmos w=2.22u l=0.84u m=1
RT282 vdd well_282 ntap1 A=4e-12 P=8e-6
MM6_4 voutp voutn vdd well_282 sg13_lv_pmos w=2.22u l=0.84u m=1
RT283 vdd well_283 ntap1 A=4e-12 P=8e-6
MM6_5 voutp voutn vdd well_283 sg13_lv_pmos w=2.22u l=0.84u m=1
RT284 vdd well_284 ntap1 A=4e-12 P=8e-6
MM6_6 voutp voutn vdd well_284 sg13_lv_pmos w=2.22u l=0.84u m=1
RT285 vdd well_285 ntap1 A=4e-12 P=8e-6
MM6_7 voutp voutn vdd well_285 sg13_lv_pmos w=2.22u l=0.84u m=1
RT286 vdd well_286 ntap1 A=4e-12 P=8e-6
MM6_8 voutp voutn vdd well_286 sg13_lv_pmos w=2.22u l=0.84u m=1
RT287 vdd well_287 ntap1 A=4e-12 P=8e-6
MM6_9 voutp voutn vdd well_287 sg13_lv_pmos w=2.22u l=0.84u m=1
RT288 vdd well_288 ntap1 A=4e-12 P=8e-6
MM6_10 voutp voutn vdd well_288 sg13_lv_pmos w=2.22u l=0.84u m=1
RT289 vdd well_289 ntap1 A=4e-12 P=8e-6
MM6_11 voutp voutn vdd well_289 sg13_lv_pmos w=2.22u l=0.84u m=1
RT290 vdd well_290 ntap1 A=4e-12 P=8e-6
MM6_12 voutp voutn vdd well_290 sg13_lv_pmos w=2.22u l=0.84u m=1
RT291 vdd well_291 ntap1 A=4e-12 P=8e-6
MM6_13 voutp voutn vdd well_291 sg13_lv_pmos w=2.22u l=0.84u m=1
RT292 vdd well_292 ntap1 A=4e-12 P=8e-6
MM6_14 voutp voutn vdd well_292 sg13_lv_pmos w=2.22u l=0.84u m=1
RT293 vdd well_293 ntap1 A=4e-12 P=8e-6
MM6_15 voutp voutn vdd well_293 sg13_lv_pmos w=2.22u l=0.84u m=1
RT294 vdd well_294 ntap1 A=4e-12 P=8e-6
MM61_0 net7 vb2 net6 well_294 sg13_lv_pmos w=2.22u l=0.84u m=1
RT295 vdd well_295 ntap1 A=4e-12 P=8e-6
MM61_1 net7 vb2 net6 well_295 sg13_lv_pmos w=2.22u l=0.84u m=1
RT296 vdd well_296 ntap1 A=4e-12 P=8e-6
MM61_2 net7 vb2 net6 well_296 sg13_lv_pmos w=2.22u l=0.84u m=1
RT297 vdd well_297 ntap1 A=4e-12 P=8e-6
MM61_3 net7 vb2 net6 well_297 sg13_lv_pmos w=2.22u l=0.84u m=1
RT298 vdd well_298 ntap1 A=4e-12 P=8e-6
MM61_4 net7 vb2 net6 well_298 sg13_lv_pmos w=2.22u l=0.84u m=1
RT299 vdd well_299 ntap1 A=4e-12 P=8e-6
MM61_5 net7 vb2 net6 well_299 sg13_lv_pmos w=2.22u l=0.84u m=1
RT300 vdd well_300 ntap1 A=4e-12 P=8e-6
MM61_6 net7 vb2 net6 well_300 sg13_lv_pmos w=2.22u l=0.84u m=1
RT301 vdd well_301 ntap1 A=4e-12 P=8e-6
MM61_7 net7 vb2 net6 well_301 sg13_lv_pmos w=2.22u l=0.84u m=1
RT302 vdd well_302 ntap1 A=4e-12 P=8e-6
MM61_8 net7 vb2 net6 well_302 sg13_lv_pmos w=2.22u l=0.84u m=1
RT303 vdd well_303 ntap1 A=4e-12 P=8e-6
MM61_9 net7 vb2 net6 well_303 sg13_lv_pmos w=2.22u l=0.84u m=1
RT304 vdd well_304 ntap1 A=4e-12 P=8e-6
MM61_10 net7 vb2 net6 well_304 sg13_lv_pmos w=2.22u l=0.84u m=1
RT305 vdd well_305 ntap1 A=4e-12 P=8e-6
MM61_11 net7 vb2 net6 well_305 sg13_lv_pmos w=2.22u l=0.84u m=1
RT306 vdd well_306 ntap1 A=4e-12 P=8e-6
MM61_12 net7 vb2 net6 well_306 sg13_lv_pmos w=2.22u l=0.84u m=1
RT307 vdd well_307 ntap1 A=4e-12 P=8e-6
MM61_13 net7 vb2 net6 well_307 sg13_lv_pmos w=2.22u l=0.84u m=1
RT308 vdd well_308 ntap1 A=4e-12 P=8e-6
MM61_14 net7 vb2 net6 well_308 sg13_lv_pmos w=2.22u l=0.84u m=1
RT309 vdd well_309 ntap1 A=4e-12 P=8e-6
MM61_15 net7 vb2 net6 well_309 sg13_lv_pmos w=2.22u l=0.84u m=1
RT310 vdd well_310 ntap1 A=4e-12 P=8e-6
MM62_0 vb3 vb2 net8 well_310 sg13_lv_pmos w=2.22u l=0.84u m=1
RT311 vdd well_311 ntap1 A=4e-12 P=8e-6
MM62_1 vb3 vb2 net8 well_311 sg13_lv_pmos w=2.22u l=0.84u m=1
RT312 vdd well_312 ntap1 A=4e-12 P=8e-6
MM62_2 vb3 vb2 net8 well_312 sg13_lv_pmos w=2.22u l=0.84u m=1
RT313 vdd well_313 ntap1 A=4e-12 P=8e-6
MM62_3 vb3 vb2 net8 well_313 sg13_lv_pmos w=2.22u l=0.84u m=1
RT314 vdd well_314 ntap1 A=4e-12 P=8e-6
MM62_4 vb3 vb2 net8 well_314 sg13_lv_pmos w=2.22u l=0.84u m=1
RT315 vdd well_315 ntap1 A=4e-12 P=8e-6
MM62_5 vb3 vb2 net8 well_315 sg13_lv_pmos w=2.22u l=0.84u m=1
RT316 vdd well_316 ntap1 A=4e-12 P=8e-6
MM62_6 vb3 vb2 net8 well_316 sg13_lv_pmos w=2.22u l=0.84u m=1
RT317 vdd well_317 ntap1 A=4e-12 P=8e-6
MM62_7 vb3 vb2 net8 well_317 sg13_lv_pmos w=2.22u l=0.84u m=1
RT318 vdd well_318 ntap1 A=4e-12 P=8e-6
MM62_8 vb3 vb2 net8 well_318 sg13_lv_pmos w=2.22u l=0.84u m=1
RT319 vdd well_319 ntap1 A=4e-12 P=8e-6
MM62_9 vb3 vb2 net8 well_319 sg13_lv_pmos w=2.22u l=0.84u m=1
RT320 vdd well_320 ntap1 A=4e-12 P=8e-6
MM62_10 vb3 vb2 net8 well_320 sg13_lv_pmos w=2.22u l=0.84u m=1
RT321 vdd well_321 ntap1 A=4e-12 P=8e-6
MM62_11 vb3 vb2 net8 well_321 sg13_lv_pmos w=2.22u l=0.84u m=1
RT322 vdd well_322 ntap1 A=4e-12 P=8e-6
MM62_12 vb3 vb2 net8 well_322 sg13_lv_pmos w=2.22u l=0.84u m=1
RT323 vdd well_323 ntap1 A=4e-12 P=8e-6
MM62_13 vb3 vb2 net8 well_323 sg13_lv_pmos w=2.22u l=0.84u m=1
RT324 vdd well_324 ntap1 A=4e-12 P=8e-6
MM62_14 vb3 vb2 net8 well_324 sg13_lv_pmos w=2.22u l=0.84u m=1
RT325 vdd well_325 ntap1 A=4e-12 P=8e-6
MM62_15 vb3 vb2 net8 well_325 sg13_lv_pmos w=2.22u l=0.84u m=1
RT326 vss sub ptap1 A=4e-12 P=8e-6
MM63_0 vb2 vb3 net9 sub sg13_lv_nmos w=0.47u l=2.1u m=1
RT327 vss sub ptap1 A=4e-12 P=8e-6
MM63_1 vb2 vb3 net9 sub sg13_lv_nmos w=0.47u l=2.1u m=1
RT328 vss sub ptap1 A=4e-12 P=8e-6
MM63_2 vb2 vb3 net9 sub sg13_lv_nmos w=0.47u l=2.1u m=1
RT329 vss sub ptap1 A=4e-12 P=8e-6
MM63_3 vb2 vb3 net9 sub sg13_lv_nmos w=0.47u l=2.1u m=1
RT330 vss sub ptap1 A=4e-12 P=8e-6
MM63_4 vb2 vb3 net9 sub sg13_lv_nmos w=0.47u l=2.1u m=1
RT331 vss sub ptap1 A=4e-12 P=8e-6
MM63_5 vb2 vb3 net9 sub sg13_lv_nmos w=0.47u l=2.1u m=1
RT332 vss sub ptap1 A=4e-12 P=8e-6
MM63_6 vb2 vb3 net9 sub sg13_lv_nmos w=0.47u l=2.1u m=1
RT333 vss sub ptap1 A=4e-12 P=8e-6
MM63_7 vb2 vb3 net9 sub sg13_lv_nmos w=0.47u l=2.1u m=1
RT334 vss sub ptap1 A=4e-12 P=8e-6
MM64_0 net9 vb4 vss sub sg13_lv_nmos w=0.47u l=2.1u m=1
RT335 vss sub ptap1 A=4e-12 P=8e-6
MM64_1 net9 vb4 vss sub sg13_lv_nmos w=0.47u l=2.1u m=1
RT336 vss sub ptap1 A=4e-12 P=8e-6
MM64_2 net9 vb4 vss sub sg13_lv_nmos w=0.47u l=2.1u m=1
RT337 vss sub ptap1 A=4e-12 P=8e-6
MM64_3 net9 vb4 vss sub sg13_lv_nmos w=0.47u l=2.1u m=1
RT338 vss sub ptap1 A=4e-12 P=8e-6
MM64_4 net9 vb4 vss sub sg13_lv_nmos w=0.47u l=2.1u m=1
RT339 vss sub ptap1 A=4e-12 P=8e-6
MM64_5 net9 vb4 vss sub sg13_lv_nmos w=0.47u l=2.1u m=1
RT340 vss sub ptap1 A=4e-12 P=8e-6
MM64_6 net9 vb4 vss sub sg13_lv_nmos w=0.47u l=2.1u m=1
RT341 vss sub ptap1 A=4e-12 P=8e-6
MM64_7 net9 vb4 vss sub sg13_lv_nmos w=0.47u l=2.1u m=1
RT342 vdd well_342 ntap1 A=4e-12 P=8e-6
MM65_0 vb2 vb2 vdd well_342 sg13_lv_pmos w=2.22u l=0.84u m=1
RT343 vdd well_343 ntap1 A=4e-12 P=8e-6
MM65_1 vb2 vb2 vdd well_343 sg13_lv_pmos w=2.22u l=0.84u m=1
RT344 vdd well_344 ntap1 A=4e-12 P=8e-6
MM65_2 vb2 vb2 vdd well_344 sg13_lv_pmos w=2.22u l=0.84u m=1
RT345 vdd well_345 ntap1 A=4e-12 P=8e-6
MM65_3 vb2 vb2 vdd well_345 sg13_lv_pmos w=2.22u l=0.84u m=1
RT346 vdd well_346 ntap1 A=4e-12 P=8e-6
MM66_0 net10 vb2 net049 well_346 sg13_lv_pmos w=0.97u l=0.81u m=1
RT347 vdd well_347 ntap1 A=4e-12 P=8e-6
MM66_1 net10 vb2 net049 well_347 sg13_lv_pmos w=0.97u l=0.81u m=1
RT348 vdd well_348 ntap1 A=4e-12 P=8e-6
MM66_2 net10 vb2 net049 well_348 sg13_lv_pmos w=0.97u l=0.81u m=1
RT349 vdd well_349 ntap1 A=4e-12 P=8e-6
MM66_3 net10 vb2 net049 well_349 sg13_lv_pmos w=0.97u l=0.81u m=1
RT350 vdd well_350 ntap1 A=4e-12 P=8e-6
MM66_4 net10 vb2 net049 well_350 sg13_lv_pmos w=0.97u l=0.81u m=1
RT351 vdd well_351 ntap1 A=4e-12 P=8e-6
MM66_5 net10 vb2 net049 well_351 sg13_lv_pmos w=0.97u l=0.81u m=1
RT352 vdd well_352 ntap1 A=4e-12 P=8e-6
MM66_6 net10 vb2 net049 well_352 sg13_lv_pmos w=0.97u l=0.81u m=1
RT353 vdd well_353 ntap1 A=4e-12 P=8e-6
MM66_7 net10 vb2 net049 well_353 sg13_lv_pmos w=0.97u l=0.81u m=1
RT354 vdd well_354 ntap1 A=4e-12 P=8e-6
MM66_8 net10 vb2 net049 well_354 sg13_lv_pmos w=0.97u l=0.81u m=1
RT355 vdd well_355 ntap1 A=4e-12 P=8e-6
MM66_9 net10 vb2 net049 well_355 sg13_lv_pmos w=0.97u l=0.81u m=1
RT356 vdd well_356 ntap1 A=4e-12 P=8e-6
MM66_10 net10 vb2 net049 well_356 sg13_lv_pmos w=0.97u l=0.81u m=1
RT357 vdd well_357 ntap1 A=4e-12 P=8e-6
MM66_11 net10 vb2 net049 well_357 sg13_lv_pmos w=0.97u l=0.81u m=1
RT358 vdd well_358 ntap1 A=4e-12 P=8e-6
MM66_12 net10 vb2 net049 well_358 sg13_lv_pmos w=0.97u l=0.81u m=1
RT359 vdd well_359 ntap1 A=4e-12 P=8e-6
MM66_13 net10 vb2 net049 well_359 sg13_lv_pmos w=0.97u l=0.81u m=1
RT360 vdd well_360 ntap1 A=4e-12 P=8e-6
MM66_14 net10 vb2 net049 well_360 sg13_lv_pmos w=0.97u l=0.81u m=1
RT361 vdd well_361 ntap1 A=4e-12 P=8e-6
MM66_15 net10 vb2 net049 well_361 sg13_lv_pmos w=0.97u l=0.81u m=1
RT362 vss sub ptap1 A=4e-12 P=8e-6
MM67_0 net043 vb3 net1 sub sg13_lv_nmos w=0.47u l=2.1u m=1
RT363 vss sub ptap1 A=4e-12 P=8e-6
MM67_1 net043 vb3 net1 sub sg13_lv_nmos w=0.47u l=2.1u m=1
RT364 vss sub ptap1 A=4e-12 P=8e-6
MM67_2 net043 vb3 net1 sub sg13_lv_nmos w=0.47u l=2.1u m=1
RT365 vss sub ptap1 A=4e-12 P=8e-6
MM67_3 net043 vb3 net1 sub sg13_lv_nmos w=0.47u l=2.1u m=1
RT366 vss sub ptap1 A=4e-12 P=8e-6
MM67_4 net043 vb3 net1 sub sg13_lv_nmos w=0.47u l=2.1u m=1
RT367 vss sub ptap1 A=4e-12 P=8e-6
MM67_5 net043 vb3 net1 sub sg13_lv_nmos w=0.47u l=2.1u m=1
RT368 vss sub ptap1 A=4e-12 P=8e-6
MM67_6 net043 vb3 net1 sub sg13_lv_nmos w=0.47u l=2.1u m=1
RT369 vss sub ptap1 A=4e-12 P=8e-6
MM67_7 net043 vb3 net1 sub sg13_lv_nmos w=0.47u l=2.1u m=1
RT370 vss sub ptap1 A=4e-12 P=8e-6
MM67_8 net043 vb3 net1 sub sg13_lv_nmos w=0.47u l=2.1u m=1
RT371 vss sub ptap1 A=4e-12 P=8e-6
MM67_9 net043 vb3 net1 sub sg13_lv_nmos w=0.47u l=2.1u m=1
RT372 vss sub ptap1 A=4e-12 P=8e-6
MM67_10 net043 vb3 net1 sub sg13_lv_nmos w=0.47u l=2.1u m=1
RT373 vss sub ptap1 A=4e-12 P=8e-6
MM67_11 net043 vb3 net1 sub sg13_lv_nmos w=0.47u l=2.1u m=1
RT374 vss sub ptap1 A=4e-12 P=8e-6
MM67_12 net043 vb3 net1 sub sg13_lv_nmos w=0.47u l=2.1u m=1
RT375 vss sub ptap1 A=4e-12 P=8e-6
MM67_13 net043 vb3 net1 sub sg13_lv_nmos w=0.47u l=2.1u m=1
RT376 vss sub ptap1 A=4e-12 P=8e-6
MM67_14 net043 vb3 net1 sub sg13_lv_nmos w=0.47u l=2.1u m=1
RT377 vss sub ptap1 A=4e-12 P=8e-6
MM67_15 net043 vb3 net1 sub sg13_lv_nmos w=0.47u l=2.1u m=1
RT378 vss sub ptap1 A=4e-12 P=8e-6
MM67_16 net043 vb3 net1 sub sg13_lv_nmos w=0.47u l=2.1u m=1
RT379 vss sub ptap1 A=4e-12 P=8e-6
MM67_17 net043 vb3 net1 sub sg13_lv_nmos w=0.47u l=2.1u m=1
RT380 vss sub ptap1 A=4e-12 P=8e-6
MM67_18 net043 vb3 net1 sub sg13_lv_nmos w=0.47u l=2.1u m=1
RT381 vss sub ptap1 A=4e-12 P=8e-6
MM67_19 net043 vb3 net1 sub sg13_lv_nmos w=0.47u l=2.1u m=1
RT382 vss sub ptap1 A=4e-12 P=8e-6
MM67_20 net043 vb3 net1 sub sg13_lv_nmos w=0.47u l=2.1u m=1
RT383 vss sub ptap1 A=4e-12 P=8e-6
MM67_21 net043 vb3 net1 sub sg13_lv_nmos w=0.47u l=2.1u m=1
RT384 vss sub ptap1 A=4e-12 P=8e-6
MM67_22 net043 vb3 net1 sub sg13_lv_nmos w=0.47u l=2.1u m=1
RT385 vss sub ptap1 A=4e-12 P=8e-6
MM67_23 net043 vb3 net1 sub sg13_lv_nmos w=0.47u l=2.1u m=1
RT386 vss sub ptap1 A=4e-12 P=8e-6
MM67_24 net043 vb3 net1 sub sg13_lv_nmos w=0.47u l=2.1u m=1
RT387 vss sub ptap1 A=4e-12 P=8e-6
MM67_25 net043 vb3 net1 sub sg13_lv_nmos w=0.47u l=2.1u m=1
RT388 vss sub ptap1 A=4e-12 P=8e-6
MM67_26 net043 vb3 net1 sub sg13_lv_nmos w=0.47u l=2.1u m=1
RT389 vss sub ptap1 A=4e-12 P=8e-6
MM67_27 net043 vb3 net1 sub sg13_lv_nmos w=0.47u l=2.1u m=1
RT390 vss sub ptap1 A=4e-12 P=8e-6
MM67_28 net043 vb3 net1 sub sg13_lv_nmos w=0.47u l=2.1u m=1
RT391 vss sub ptap1 A=4e-12 P=8e-6
MM67_29 net043 vb3 net1 sub sg13_lv_nmos w=0.47u l=2.1u m=1
RT392 vss sub ptap1 A=4e-12 P=8e-6
MM67_30 net043 vb3 net1 sub sg13_lv_nmos w=0.47u l=2.1u m=1
RT393 vss sub ptap1 A=4e-12 P=8e-6
MM67_31 net043 vb3 net1 sub sg13_lv_nmos w=0.47u l=2.1u m=1
RT394 vss sub ptap1 A=4e-12 P=8e-6
MM67_32 net043 vb3 net1 sub sg13_lv_nmos w=0.47u l=2.1u m=1
RT395 vss sub ptap1 A=4e-12 P=8e-6
MM67_33 net043 vb3 net1 sub sg13_lv_nmos w=0.47u l=2.1u m=1
RT396 vss sub ptap1 A=4e-12 P=8e-6
MM67_34 net043 vb3 net1 sub sg13_lv_nmos w=0.47u l=2.1u m=1
RT397 vss sub ptap1 A=4e-12 P=8e-6
MM67_35 net043 vb3 net1 sub sg13_lv_nmos w=0.47u l=2.1u m=1
RT398 vss sub ptap1 A=4e-12 P=8e-6
MM67_36 net043 vb3 net1 sub sg13_lv_nmos w=0.47u l=2.1u m=1
RT399 vss sub ptap1 A=4e-12 P=8e-6
MM67_37 net043 vb3 net1 sub sg13_lv_nmos w=0.47u l=2.1u m=1
RT400 vss sub ptap1 A=4e-12 P=8e-6
MM67_38 net043 vb3 net1 sub sg13_lv_nmos w=0.47u l=2.1u m=1
RT401 vss sub ptap1 A=4e-12 P=8e-6
MM67_39 net043 vb3 net1 sub sg13_lv_nmos w=0.47u l=2.1u m=1
RT402 vss sub ptap1 A=4e-12 P=8e-6
MM67_40 net043 vb3 net1 sub sg13_lv_nmos w=0.47u l=2.1u m=1
RT403 vss sub ptap1 A=4e-12 P=8e-6
MM67_41 net043 vb3 net1 sub sg13_lv_nmos w=0.47u l=2.1u m=1
RT404 vss sub ptap1 A=4e-12 P=8e-6
MM67_42 net043 vb3 net1 sub sg13_lv_nmos w=0.47u l=2.1u m=1
RT405 vss sub ptap1 A=4e-12 P=8e-6
MM67_43 net043 vb3 net1 sub sg13_lv_nmos w=0.47u l=2.1u m=1
RT406 vss sub ptap1 A=4e-12 P=8e-6
MM67_44 net043 vb3 net1 sub sg13_lv_nmos w=0.47u l=2.1u m=1
RT407 vss sub ptap1 A=4e-12 P=8e-6
MM67_45 net043 vb3 net1 sub sg13_lv_nmos w=0.47u l=2.1u m=1
RT408 vss sub ptap1 A=4e-12 P=8e-6
MM67_46 net043 vb3 net1 sub sg13_lv_nmos w=0.47u l=2.1u m=1
RT409 vss sub ptap1 A=4e-12 P=8e-6
MM67_47 net043 vb3 net1 sub sg13_lv_nmos w=0.47u l=2.1u m=1
RT410 vss sub ptap1 A=4e-12 P=8e-6
MM67_48 net043 vb3 net1 sub sg13_lv_nmos w=0.47u l=2.1u m=1
RT411 vss sub ptap1 A=4e-12 P=8e-6
MM67_49 net043 vb3 net1 sub sg13_lv_nmos w=0.47u l=2.1u m=1
RT412 vss sub ptap1 A=4e-12 P=8e-6
MM67_50 net043 vb3 net1 sub sg13_lv_nmos w=0.47u l=2.1u m=1
RT413 vss sub ptap1 A=4e-12 P=8e-6
MM67_51 net043 vb3 net1 sub sg13_lv_nmos w=0.47u l=2.1u m=1
RT414 vss sub ptap1 A=4e-12 P=8e-6
MM67_52 net043 vb3 net1 sub sg13_lv_nmos w=0.47u l=2.1u m=1
RT415 vss sub ptap1 A=4e-12 P=8e-6
MM67_53 net043 vb3 net1 sub sg13_lv_nmos w=0.47u l=2.1u m=1
RT416 vss sub ptap1 A=4e-12 P=8e-6
MM67_54 net043 vb3 net1 sub sg13_lv_nmos w=0.47u l=2.1u m=1
RT417 vss sub ptap1 A=4e-12 P=8e-6
MM67_55 net043 vb3 net1 sub sg13_lv_nmos w=0.47u l=2.1u m=1
RT418 vss sub ptap1 A=4e-12 P=8e-6
MM67_56 net043 vb3 net1 sub sg13_lv_nmos w=0.47u l=2.1u m=1
RT419 vss sub ptap1 A=4e-12 P=8e-6
MM67_57 net043 vb3 net1 sub sg13_lv_nmos w=0.47u l=2.1u m=1
RT420 vss sub ptap1 A=4e-12 P=8e-6
MM67_58 net043 vb3 net1 sub sg13_lv_nmos w=0.47u l=2.1u m=1
RT421 vss sub ptap1 A=4e-12 P=8e-6
MM67_59 net043 vb3 net1 sub sg13_lv_nmos w=0.47u l=2.1u m=1
RT422 vss sub ptap1 A=4e-12 P=8e-6
MM67_60 net043 vb3 net1 sub sg13_lv_nmos w=0.47u l=2.1u m=1
RT423 vss sub ptap1 A=4e-12 P=8e-6
MM67_61 net043 vb3 net1 sub sg13_lv_nmos w=0.47u l=2.1u m=1
RT424 vss sub ptap1 A=4e-12 P=8e-6
MM67_62 net043 vb3 net1 sub sg13_lv_nmos w=0.47u l=2.1u m=1
RT425 vss sub ptap1 A=4e-12 P=8e-6
MM67_63 net043 vb3 net1 sub sg13_lv_nmos w=0.47u l=2.1u m=1
RT426 vss sub ptap1 A=4e-12 P=8e-6
MM68_0 net1 vb4 vss sub sg13_lv_nmos w=8.71u l=2.9u m=1
RT427 vss sub ptap1 A=4e-12 P=8e-6
MM68_1 net1 vb4 vss sub sg13_lv_nmos w=8.71u l=2.9u m=1
RT428 vss sub ptap1 A=4e-12 P=8e-6
MM68_2 net1 vb4 vss sub sg13_lv_nmos w=8.71u l=2.9u m=1
RT429 vss sub ptap1 A=4e-12 P=8e-6
MM69_0 net10 net043 vss sub sg13_lv_nmos w=1.68u l=8.05u m=1
RT430 vss sub ptap1 A=4e-12 P=8e-6
MM69_1 net10 net043 vss sub sg13_lv_nmos w=1.68u l=8.05u m=1
RT431 vss sub ptap1 A=4e-12 P=8e-6
MM69_2 net10 net043 vss sub sg13_lv_nmos w=1.68u l=8.05u m=1
RT432 vdd well_432 ntap1 A=4e-12 P=8e-6
MM7_0 net049 vb1 vdd well_432 sg13_lv_pmos w=2.22u l=0.84u m=1
RT433 vdd well_433 ntap1 A=4e-12 P=8e-6
MM7_1 net049 vb1 vdd well_433 sg13_lv_pmos w=2.22u l=0.84u m=1
RT434 vdd well_434 ntap1 A=4e-12 P=8e-6
MM7_2 net049 vb1 vdd well_434 sg13_lv_pmos w=2.22u l=0.84u m=1
RT435 vdd well_435 ntap1 A=4e-12 P=8e-6
MM7_3 net049 vb1 vdd well_435 sg13_lv_pmos w=2.22u l=0.84u m=1
RT436 vdd well_436 ntap1 A=4e-12 P=8e-6
MM7_4 net049 vb1 vdd well_436 sg13_lv_pmos w=2.22u l=0.84u m=1
RT437 vdd well_437 ntap1 A=4e-12 P=8e-6
MM7_5 net049 vb1 vdd well_437 sg13_lv_pmos w=2.22u l=0.84u m=1
RT438 vdd well_438 ntap1 A=4e-12 P=8e-6
MM7_6 net049 vb1 vdd well_438 sg13_lv_pmos w=2.22u l=0.84u m=1
RT439 vdd well_439 ntap1 A=4e-12 P=8e-6
MM7_7 net049 vb1 vdd well_439 sg13_lv_pmos w=2.22u l=0.84u m=1
RT440 vdd well_440 ntap1 A=4e-12 P=8e-6
MM7_8 net049 vb1 vdd well_440 sg13_lv_pmos w=2.22u l=0.84u m=1
RT441 vdd well_441 ntap1 A=4e-12 P=8e-6
MM7_9 net049 vb1 vdd well_441 sg13_lv_pmos w=2.22u l=0.84u m=1
RT442 vdd well_442 ntap1 A=4e-12 P=8e-6
MM7_10 net049 vb1 vdd well_442 sg13_lv_pmos w=2.22u l=0.84u m=1
RT443 vdd well_443 ntap1 A=4e-12 P=8e-6
MM7_11 net049 vb1 vdd well_443 sg13_lv_pmos w=2.22u l=0.84u m=1
RT444 vdd well_444 ntap1 A=4e-12 P=8e-6
MM7_12 net049 vb1 vdd well_444 sg13_lv_pmos w=2.22u l=0.84u m=1
RT445 vdd well_445 ntap1 A=4e-12 P=8e-6
MM7_13 net049 vb1 vdd well_445 sg13_lv_pmos w=2.22u l=0.84u m=1
RT446 vdd well_446 ntap1 A=4e-12 P=8e-6
MM7_14 net049 vb1 vdd well_446 sg13_lv_pmos w=2.22u l=0.84u m=1
RT447 vdd well_447 ntap1 A=4e-12 P=8e-6
MM7_15 net049 vb1 vdd well_447 sg13_lv_pmos w=2.22u l=0.84u m=1
RT448 vdd well_448 ntap1 A=4e-12 P=8e-6
MM7_16 net049 vb1 vdd well_448 sg13_lv_pmos w=2.22u l=0.84u m=1
RT449 vdd well_449 ntap1 A=4e-12 P=8e-6
MM7_17 net049 vb1 vdd well_449 sg13_lv_pmos w=2.22u l=0.84u m=1
RT450 vdd well_450 ntap1 A=4e-12 P=8e-6
MM7_18 net049 vb1 vdd well_450 sg13_lv_pmos w=2.22u l=0.84u m=1
RT451 vdd well_451 ntap1 A=4e-12 P=8e-6
MM7_19 net049 vb1 vdd well_451 sg13_lv_pmos w=2.22u l=0.84u m=1
RT452 vdd well_452 ntap1 A=4e-12 P=8e-6
MM7_20 net049 vb1 vdd well_452 sg13_lv_pmos w=2.22u l=0.84u m=1
RT453 vdd well_453 ntap1 A=4e-12 P=8e-6
MM7_21 net049 vb1 vdd well_453 sg13_lv_pmos w=2.22u l=0.84u m=1
RT454 vdd well_454 ntap1 A=4e-12 P=8e-6
MM7_22 net049 vb1 vdd well_454 sg13_lv_pmos w=2.22u l=0.84u m=1
RT455 vdd well_455 ntap1 A=4e-12 P=8e-6
MM7_23 net049 vb1 vdd well_455 sg13_lv_pmos w=2.22u l=0.84u m=1
RT456 vdd well_456 ntap1 A=4e-12 P=8e-6
MM7_24 net049 vb1 vdd well_456 sg13_lv_pmos w=2.22u l=0.84u m=1
RT457 vdd well_457 ntap1 A=4e-12 P=8e-6
MM7_25 net049 vb1 vdd well_457 sg13_lv_pmos w=2.22u l=0.84u m=1
RT458 vdd well_458 ntap1 A=4e-12 P=8e-6
MM7_26 net049 vb1 vdd well_458 sg13_lv_pmos w=2.22u l=0.84u m=1
RT459 vdd well_459 ntap1 A=4e-12 P=8e-6
MM7_27 net049 vb1 vdd well_459 sg13_lv_pmos w=2.22u l=0.84u m=1
RT460 vdd well_460 ntap1 A=4e-12 P=8e-6
MM7_28 net049 vb1 vdd well_460 sg13_lv_pmos w=2.22u l=0.84u m=1
RT461 vdd well_461 ntap1 A=4e-12 P=8e-6
MM7_29 net049 vb1 vdd well_461 sg13_lv_pmos w=2.22u l=0.84u m=1
RT462 vdd well_462 ntap1 A=4e-12 P=8e-6
MM7_30 net049 vb1 vdd well_462 sg13_lv_pmos w=2.22u l=0.84u m=1
RT463 vdd well_463 ntap1 A=4e-12 P=8e-6
MM7_31 net049 vb1 vdd well_463 sg13_lv_pmos w=2.22u l=0.84u m=1
RT464 vdd well_464 ntap1 A=4e-12 P=8e-6
MM7_32 net049 vb1 vdd well_464 sg13_lv_pmos w=2.22u l=0.84u m=1
RT465 vdd well_465 ntap1 A=4e-12 P=8e-6
MM7_33 net049 vb1 vdd well_465 sg13_lv_pmos w=2.22u l=0.84u m=1
RT466 vdd well_466 ntap1 A=4e-12 P=8e-6
MM7_34 net049 vb1 vdd well_466 sg13_lv_pmos w=2.22u l=0.84u m=1
RT467 vdd well_467 ntap1 A=4e-12 P=8e-6
MM7_35 net049 vb1 vdd well_467 sg13_lv_pmos w=2.22u l=0.84u m=1
RT468 vdd well_468 ntap1 A=4e-12 P=8e-6
MM7_36 net049 vb1 vdd well_468 sg13_lv_pmos w=2.22u l=0.84u m=1
RT469 vdd well_469 ntap1 A=4e-12 P=8e-6
MM7_37 net049 vb1 vdd well_469 sg13_lv_pmos w=2.22u l=0.84u m=1
RT470 vdd well_470 ntap1 A=4e-12 P=8e-6
MM7_38 net049 vb1 vdd well_470 sg13_lv_pmos w=2.22u l=0.84u m=1
RT471 vdd well_471 ntap1 A=4e-12 P=8e-6
MM7_39 net049 vb1 vdd well_471 sg13_lv_pmos w=2.22u l=0.84u m=1
RT472 vdd well_472 ntap1 A=4e-12 P=8e-6
MM7_40 net049 vb1 vdd well_472 sg13_lv_pmos w=2.22u l=0.84u m=1
RT473 vdd well_473 ntap1 A=4e-12 P=8e-6
MM7_41 net049 vb1 vdd well_473 sg13_lv_pmos w=2.22u l=0.84u m=1
RT474 vdd well_474 ntap1 A=4e-12 P=8e-6
MM7_42 net049 vb1 vdd well_474 sg13_lv_pmos w=2.22u l=0.84u m=1
RT475 vdd well_475 ntap1 A=4e-12 P=8e-6
MM7_43 net049 vb1 vdd well_475 sg13_lv_pmos w=2.22u l=0.84u m=1
RT476 vdd well_476 ntap1 A=4e-12 P=8e-6
MM7_44 net049 vb1 vdd well_476 sg13_lv_pmos w=2.22u l=0.84u m=1
RT477 vdd well_477 ntap1 A=4e-12 P=8e-6
MM7_45 net049 vb1 vdd well_477 sg13_lv_pmos w=2.22u l=0.84u m=1
RT478 vdd well_478 ntap1 A=4e-12 P=8e-6
MM7_46 net049 vb1 vdd well_478 sg13_lv_pmos w=2.22u l=0.84u m=1
RT479 vdd well_479 ntap1 A=4e-12 P=8e-6
MM7_47 net049 vb1 vdd well_479 sg13_lv_pmos w=2.22u l=0.84u m=1
RT480 vdd well_480 ntap1 A=4e-12 P=8e-6
MM7_48 net049 vb1 vdd well_480 sg13_lv_pmos w=2.22u l=0.84u m=1
RT481 vdd well_481 ntap1 A=4e-12 P=8e-6
MM7_49 net049 vb1 vdd well_481 sg13_lv_pmos w=2.22u l=0.84u m=1
RT482 vdd well_482 ntap1 A=4e-12 P=8e-6
MM7_50 net049 vb1 vdd well_482 sg13_lv_pmos w=2.22u l=0.84u m=1
RT483 vdd well_483 ntap1 A=4e-12 P=8e-6
MM7_51 net049 vb1 vdd well_483 sg13_lv_pmos w=2.22u l=0.84u m=1
RT484 vdd well_484 ntap1 A=4e-12 P=8e-6
MM7_52 net049 vb1 vdd well_484 sg13_lv_pmos w=2.22u l=0.84u m=1
RT485 vdd well_485 ntap1 A=4e-12 P=8e-6
MM7_53 net049 vb1 vdd well_485 sg13_lv_pmos w=2.22u l=0.84u m=1
RT486 vdd well_486 ntap1 A=4e-12 P=8e-6
MM7_54 net049 vb1 vdd well_486 sg13_lv_pmos w=2.22u l=0.84u m=1
RT487 vdd well_487 ntap1 A=4e-12 P=8e-6
MM7_55 net049 vb1 vdd well_487 sg13_lv_pmos w=2.22u l=0.84u m=1
RT488 vdd well_488 ntap1 A=4e-12 P=8e-6
MM7_56 net049 vb1 vdd well_488 sg13_lv_pmos w=2.22u l=0.84u m=1
RT489 vdd well_489 ntap1 A=4e-12 P=8e-6
MM7_57 net049 vb1 vdd well_489 sg13_lv_pmos w=2.22u l=0.84u m=1
RT490 vdd well_490 ntap1 A=4e-12 P=8e-6
MM7_58 net049 vb1 vdd well_490 sg13_lv_pmos w=2.22u l=0.84u m=1
RT491 vdd well_491 ntap1 A=4e-12 P=8e-6
MM7_59 net049 vb1 vdd well_491 sg13_lv_pmos w=2.22u l=0.84u m=1
RT492 vdd well_492 ntap1 A=4e-12 P=8e-6
MM7_60 net049 vb1 vdd well_492 sg13_lv_pmos w=2.22u l=0.84u m=1
RT493 vdd well_493 ntap1 A=4e-12 P=8e-6
MM7_61 net049 vb1 vdd well_493 sg13_lv_pmos w=2.22u l=0.84u m=1
RT494 vdd well_494 ntap1 A=4e-12 P=8e-6
MM7_62 net049 vb1 vdd well_494 sg13_lv_pmos w=2.22u l=0.84u m=1
RT495 vdd well_495 ntap1 A=4e-12 P=8e-6
MM7_63 net049 vb1 vdd well_495 sg13_lv_pmos w=2.22u l=0.84u m=1
RT496 vss sub ptap1 A=4e-12 P=8e-6
MM70_0 net1 net043 vss sub sg13_lv_nmos w=1.68u l=8.05u m=1
RT497 vss sub ptap1 A=4e-12 P=8e-6
MM70_1 net1 net043 vss sub sg13_lv_nmos w=1.68u l=8.05u m=1
RT498 vss sub ptap1 A=4e-12 P=8e-6
MM70_2 net1 net043 vss sub sg13_lv_nmos w=1.68u l=8.05u m=1
RT499 net31 well_499 ntap1 A=4e-12 P=8e-6
MM8_0 dm_2 vinn net31 well_499 sg13_lv_pmos w=9.9u l=1.89u m=1
RT500 net31 well_500 ntap1 A=4e-12 P=8e-6
MM8_1 dm_2 vinn net31 well_500 sg13_lv_pmos w=9.9u l=1.89u m=1
RT501 net31 well_501 ntap1 A=4e-12 P=8e-6
MM8_2 dm_2 vinn net31 well_501 sg13_lv_pmos w=9.9u l=1.89u m=1
RT502 net31 well_502 ntap1 A=4e-12 P=8e-6
MM9_0 net063 vinp net31 well_502 sg13_lv_pmos w=9.9u l=1.89u m=1
RT503 net31 well_503 ntap1 A=4e-12 P=8e-6
MM9_1 net063 vinp net31 well_503 sg13_lv_pmos w=9.9u l=1.89u m=1
RT504 net31 well_504 ntap1 A=4e-12 P=8e-6
MM9_2 net063 vinp net31 well_504 sg13_lv_pmos w=9.9u l=1.89u m=1
RTSUB vss sub ptap1 A=4e-12 P=8e-6
C0_0 voutp vout cap_cmim w=36.06u l=36.06u m=1
C1_0 net10 net4 cap_cmim w=37.96u l=37.96u m=1
C1_1 net10 net4 cap_cmim w=37.96u l=37.96u m=1
RR0_0 net4 R0_s1 sub rhigh w=.5u l=82.46u m=1 b=0
RR0_1 R0_s1 R0_s2 sub rhigh w=.5u l=82.46u m=1 b=0
RR0_2 R0_s2 R0_s3 sub rhigh w=.5u l=82.46u m=1 b=0
RR0_3 R0_s3 R0_s4 sub rhigh w=.5u l=82.46u m=1 b=0
RR0_4 R0_s4 R0_s5 sub rhigh w=.5u l=82.46u m=1 b=0
RR0_5 R0_s5 vss sub rhigh w=.5u l=82.46u m=1 b=0
.ends amp_011_peng_iac
