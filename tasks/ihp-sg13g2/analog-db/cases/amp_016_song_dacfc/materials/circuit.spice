* Copyright 2026 Danial Noori Zadeh. See collection LICENSE and NOTICE.
* Fixed IHP binding; external bias ports and native physical taps.
.subckt amp_016_song_dacfc vss vdd vinn vinp vout net013
XT0 vdd well_0 ntap1 A=4e-12 P=8e-6
XM0_0 net013 net013 vdd well_0 sg13_lv_pmos w=1u l=1u m=1
XT1 vdd well_1 ntap1 A=4e-12 P=8e-6
XM0_1 net013 net013 vdd well_1 sg13_lv_pmos w=1u l=1u m=1
XT2 vdd well_2 ntap1 A=4e-12 P=8e-6
XM0_2 net013 net013 vdd well_2 sg13_lv_pmos w=1u l=1u m=1
XT3 vdd well_3 ntap1 A=4e-12 P=8e-6
XM0_3 net013 net013 vdd well_3 sg13_lv_pmos w=1u l=1u m=1
XT4 vdd well_4 ntap1 A=4e-12 P=8e-6
XM0_4 net013 net013 vdd well_4 sg13_lv_pmos w=1u l=1u m=1
XT5 vdd well_5 ntap1 A=4e-12 P=8e-6
XM0_5 net013 net013 vdd well_5 sg13_lv_pmos w=1u l=1u m=1
XT6 vdd well_6 ntap1 A=4e-12 P=8e-6
XM0_6 net013 net013 vdd well_6 sg13_lv_pmos w=1u l=1u m=1
XT7 vdd well_7 ntap1 A=4e-12 P=8e-6
XM0_7 net013 net013 vdd well_7 sg13_lv_pmos w=1u l=1u m=1
XT8 vdd well_8 ntap1 A=4e-12 P=8e-6
XM0_8 net013 net013 vdd well_8 sg13_lv_pmos w=1u l=1u m=1
XT9 vdd well_9 ntap1 A=4e-12 P=8e-6
XM0_9 net013 net013 vdd well_9 sg13_lv_pmos w=1u l=1u m=1
XT10 vdd well_10 ntap1 A=4e-12 P=8e-6
XM0_10 net013 net013 vdd well_10 sg13_lv_pmos w=1u l=1u m=1
XT11 vdd well_11 ntap1 A=4e-12 P=8e-6
XM0_11 net013 net013 vdd well_11 sg13_lv_pmos w=1u l=1u m=1
XT12 vdd well_12 ntap1 A=4e-12 P=8e-6
XM0_12 net013 net013 vdd well_12 sg13_lv_pmos w=1u l=1u m=1
XT13 vdd well_13 ntap1 A=4e-12 P=8e-6
XM0_13 net013 net013 vdd well_13 sg13_lv_pmos w=1u l=1u m=1
XT14 vdd well_14 ntap1 A=4e-12 P=8e-6
XM0_14 net013 net013 vdd well_14 sg13_lv_pmos w=1u l=1u m=1
XT15 vdd well_15 ntap1 A=4e-12 P=8e-6
XM0_15 net013 net013 vdd well_15 sg13_lv_pmos w=1u l=1u m=1
XT16 vdd well_16 ntap1 A=4e-12 P=8e-6
XM1_0 vb4 net013 vdd well_16 sg13_lv_pmos w=1u l=1u m=1
XT17 vdd well_17 ntap1 A=4e-12 P=8e-6
XM1_1 vb4 net013 vdd well_17 sg13_lv_pmos w=1u l=1u m=1
XT18 vdd well_18 ntap1 A=4e-12 P=8e-6
XM1_2 vb4 net013 vdd well_18 sg13_lv_pmos w=1u l=1u m=1
XT19 vdd well_19 ntap1 A=4e-12 P=8e-6
XM1_3 vb4 net013 vdd well_19 sg13_lv_pmos w=1u l=1u m=1
XT20 vdd well_20 ntap1 A=4e-12 P=8e-6
XM1_4 vb4 net013 vdd well_20 sg13_lv_pmos w=1u l=1u m=1
XT21 vdd well_21 ntap1 A=4e-12 P=8e-6
XM1_5 vb4 net013 vdd well_21 sg13_lv_pmos w=1u l=1u m=1
XT22 vdd well_22 ntap1 A=4e-12 P=8e-6
XM1_6 vb4 net013 vdd well_22 sg13_lv_pmos w=1u l=1u m=1
XT23 vdd well_23 ntap1 A=4e-12 P=8e-6
XM1_7 vb4 net013 vdd well_23 sg13_lv_pmos w=1u l=1u m=1
XT24 vdd well_24 ntap1 A=4e-12 P=8e-6
XM1_8 vb4 net013 vdd well_24 sg13_lv_pmos w=1u l=1u m=1
XT25 vdd well_25 ntap1 A=4e-12 P=8e-6
XM1_9 vb4 net013 vdd well_25 sg13_lv_pmos w=1u l=1u m=1
XT26 vdd well_26 ntap1 A=4e-12 P=8e-6
XM1_10 vb4 net013 vdd well_26 sg13_lv_pmos w=1u l=1u m=1
XT27 vdd well_27 ntap1 A=4e-12 P=8e-6
XM1_11 vb4 net013 vdd well_27 sg13_lv_pmos w=1u l=1u m=1
XT28 vdd well_28 ntap1 A=4e-12 P=8e-6
XM1_12 vb4 net013 vdd well_28 sg13_lv_pmos w=1u l=1u m=1
XT29 vdd well_29 ntap1 A=4e-12 P=8e-6
XM1_13 vb4 net013 vdd well_29 sg13_lv_pmos w=1u l=1u m=1
XT30 vdd well_30 ntap1 A=4e-12 P=8e-6
XM1_14 vb4 net013 vdd well_30 sg13_lv_pmos w=1u l=1u m=1
XT31 vdd well_31 ntap1 A=4e-12 P=8e-6
XM1_15 vb4 net013 vdd well_31 sg13_lv_pmos w=1u l=1u m=1
XT32 vdd well_32 ntap1 A=4e-12 P=8e-6
XM10_0 net043 net4 vdd well_32 sg13_lv_pmos w=1u l=1u m=1
XT33 vdd well_33 ntap1 A=4e-12 P=8e-6
XM10_1 net043 net4 vdd well_33 sg13_lv_pmos w=1u l=1u m=1
XT34 vdd well_34 ntap1 A=4e-12 P=8e-6
XM10_2 net043 net4 vdd well_34 sg13_lv_pmos w=1u l=1u m=1
XT35 vdd well_35 ntap1 A=4e-12 P=8e-6
XM10_3 net043 net4 vdd well_35 sg13_lv_pmos w=1u l=1u m=1
XT36 vdd well_36 ntap1 A=4e-12 P=8e-6
XM11_0 vout net4 vdd well_36 sg13_lv_pmos w=1u l=1u m=1
XT37 vdd well_37 ntap1 A=4e-12 P=8e-6
XM11_1 vout net4 vdd well_37 sg13_lv_pmos w=1u l=1u m=1
XT38 vdd well_38 ntap1 A=4e-12 P=8e-6
XM11_2 vout net4 vdd well_38 sg13_lv_pmos w=1u l=1u m=1
XT39 vdd well_39 ntap1 A=4e-12 P=8e-6
XM11_3 vout net4 vdd well_39 sg13_lv_pmos w=1u l=1u m=1
XT40 vss sub ptap1 A=4e-12 P=8e-6
XM12_0 vb4 vb3 net54 sub sg13_lv_nmos w=1u l=1u m=1
XT41 vss sub ptap1 A=4e-12 P=8e-6
XM12_1 vb4 vb3 net54 sub sg13_lv_nmos w=1u l=1u m=1
XT42 vss sub ptap1 A=4e-12 P=8e-6
XM12_2 vb4 vb3 net54 sub sg13_lv_nmos w=1u l=1u m=1
XT43 vss sub ptap1 A=4e-12 P=8e-6
XM12_3 vb4 vb3 net54 sub sg13_lv_nmos w=1u l=1u m=1
XT44 vss sub ptap1 A=4e-12 P=8e-6
XM12_4 vb4 vb3 net54 sub sg13_lv_nmos w=1u l=1u m=1
XT45 vss sub ptap1 A=4e-12 P=8e-6
XM12_5 vb4 vb3 net54 sub sg13_lv_nmos w=1u l=1u m=1
XT46 vss sub ptap1 A=4e-12 P=8e-6
XM12_6 vb4 vb3 net54 sub sg13_lv_nmos w=1u l=1u m=1
XT47 vss sub ptap1 A=4e-12 P=8e-6
XM12_7 vb4 vb3 net54 sub sg13_lv_nmos w=1u l=1u m=1
XT48 vss sub ptap1 A=4e-12 P=8e-6
XM12_8 vb4 vb3 net54 sub sg13_lv_nmos w=1u l=1u m=1
XT49 vss sub ptap1 A=4e-12 P=8e-6
XM12_9 vb4 vb3 net54 sub sg13_lv_nmos w=1u l=1u m=1
XT50 vss sub ptap1 A=4e-12 P=8e-6
XM12_10 vb4 vb3 net54 sub sg13_lv_nmos w=1u l=1u m=1
XT51 vss sub ptap1 A=4e-12 P=8e-6
XM12_11 vb4 vb3 net54 sub sg13_lv_nmos w=1u l=1u m=1
XT52 vss sub ptap1 A=4e-12 P=8e-6
XM12_12 vb4 vb3 net54 sub sg13_lv_nmos w=1u l=1u m=1
XT53 vss sub ptap1 A=4e-12 P=8e-6
XM12_13 vb4 vb3 net54 sub sg13_lv_nmos w=1u l=1u m=1
XT54 vss sub ptap1 A=4e-12 P=8e-6
XM12_14 vb4 vb3 net54 sub sg13_lv_nmos w=1u l=1u m=1
XT55 vss sub ptap1 A=4e-12 P=8e-6
XM12_15 vb4 vb3 net54 sub sg13_lv_nmos w=1u l=1u m=1
XT56 vss sub ptap1 A=4e-12 P=8e-6
XM13_0 dm_1 vb3 net56 sub sg13_lv_nmos w=1u l=1u m=1
XT57 vss sub ptap1 A=4e-12 P=8e-6
XM13_1 dm_1 vb3 net56 sub sg13_lv_nmos w=1u l=1u m=1
XT58 vss sub ptap1 A=4e-12 P=8e-6
XM13_2 dm_1 vb3 net56 sub sg13_lv_nmos w=1u l=1u m=1
XT59 vss sub ptap1 A=4e-12 P=8e-6
XM13_3 dm_1 vb3 net56 sub sg13_lv_nmos w=1u l=1u m=1
XT60 vss sub ptap1 A=4e-12 P=8e-6
XM13_4 dm_1 vb3 net56 sub sg13_lv_nmos w=1u l=1u m=1
XT61 vss sub ptap1 A=4e-12 P=8e-6
XM13_5 dm_1 vb3 net56 sub sg13_lv_nmos w=1u l=1u m=1
XT62 vss sub ptap1 A=4e-12 P=8e-6
XM13_6 dm_1 vb3 net56 sub sg13_lv_nmos w=1u l=1u m=1
XT63 vss sub ptap1 A=4e-12 P=8e-6
XM13_7 dm_1 vb3 net56 sub sg13_lv_nmos w=1u l=1u m=1
XT64 vss sub ptap1 A=4e-12 P=8e-6
XM13_8 dm_1 vb3 net56 sub sg13_lv_nmos w=1u l=1u m=1
XT65 vss sub ptap1 A=4e-12 P=8e-6
XM13_9 dm_1 vb3 net56 sub sg13_lv_nmos w=1u l=1u m=1
XT66 vss sub ptap1 A=4e-12 P=8e-6
XM13_10 dm_1 vb3 net56 sub sg13_lv_nmos w=1u l=1u m=1
XT67 vss sub ptap1 A=4e-12 P=8e-6
XM13_11 dm_1 vb3 net56 sub sg13_lv_nmos w=1u l=1u m=1
XT68 vss sub ptap1 A=4e-12 P=8e-6
XM13_12 dm_1 vb3 net56 sub sg13_lv_nmos w=1u l=1u m=1
XT69 vss sub ptap1 A=4e-12 P=8e-6
XM13_13 dm_1 vb3 net56 sub sg13_lv_nmos w=1u l=1u m=1
XT70 vss sub ptap1 A=4e-12 P=8e-6
XM13_14 dm_1 vb3 net56 sub sg13_lv_nmos w=1u l=1u m=1
XT71 vss sub ptap1 A=4e-12 P=8e-6
XM13_15 dm_1 vb3 net56 sub sg13_lv_nmos w=1u l=1u m=1
XT72 vss sub ptap1 A=4e-12 P=8e-6
XM14_0 vb3 vb3 vss sub sg13_lv_nmos w=1u l=1u m=1
XT73 vss sub ptap1 A=4e-12 P=8e-6
XM14_1 vb3 vb3 vss sub sg13_lv_nmos w=1u l=1u m=1
XT74 vss sub ptap1 A=4e-12 P=8e-6
XM14_2 vb3 vb3 vss sub sg13_lv_nmos w=1u l=1u m=1
XT75 vss sub ptap1 A=4e-12 P=8e-6
XM14_3 vb3 vb3 vss sub sg13_lv_nmos w=1u l=1u m=1
XT76 vss sub ptap1 A=4e-12 P=8e-6
XM15_0 voutn vb3 dm_2 sub sg13_lv_nmos w=1u l=1u m=1
XT77 vss sub ptap1 A=4e-12 P=8e-6
XM15_1 voutn vb3 dm_2 sub sg13_lv_nmos w=1u l=1u m=1
XT78 vss sub ptap1 A=4e-12 P=8e-6
XM15_2 voutn vb3 dm_2 sub sg13_lv_nmos w=1u l=1u m=1
XT79 vss sub ptap1 A=4e-12 P=8e-6
XM15_3 voutn vb3 dm_2 sub sg13_lv_nmos w=1u l=1u m=1
XT80 vss sub ptap1 A=4e-12 P=8e-6
XM15_4 voutn vb3 dm_2 sub sg13_lv_nmos w=1u l=1u m=1
XT81 vss sub ptap1 A=4e-12 P=8e-6
XM15_5 voutn vb3 dm_2 sub sg13_lv_nmos w=1u l=1u m=1
XT82 vss sub ptap1 A=4e-12 P=8e-6
XM15_6 voutn vb3 dm_2 sub sg13_lv_nmos w=1u l=1u m=1
XT83 vss sub ptap1 A=4e-12 P=8e-6
XM15_7 voutn vb3 dm_2 sub sg13_lv_nmos w=1u l=1u m=1
XT84 vss sub ptap1 A=4e-12 P=8e-6
XM15_8 voutn vb3 dm_2 sub sg13_lv_nmos w=1u l=1u m=1
XT85 vss sub ptap1 A=4e-12 P=8e-6
XM15_9 voutn vb3 dm_2 sub sg13_lv_nmos w=1u l=1u m=1
XT86 vss sub ptap1 A=4e-12 P=8e-6
XM15_10 voutn vb3 dm_2 sub sg13_lv_nmos w=1u l=1u m=1
XT87 vss sub ptap1 A=4e-12 P=8e-6
XM15_11 voutn vb3 dm_2 sub sg13_lv_nmos w=1u l=1u m=1
XT88 vss sub ptap1 A=4e-12 P=8e-6
XM15_12 voutn vb3 dm_2 sub sg13_lv_nmos w=1u l=1u m=1
XT89 vss sub ptap1 A=4e-12 P=8e-6
XM15_13 voutn vb3 dm_2 sub sg13_lv_nmos w=1u l=1u m=1
XT90 vss sub ptap1 A=4e-12 P=8e-6
XM15_14 voutn vb3 dm_2 sub sg13_lv_nmos w=1u l=1u m=1
XT91 vss sub ptap1 A=4e-12 P=8e-6
XM15_15 voutn vb3 dm_2 sub sg13_lv_nmos w=1u l=1u m=1
XT92 vss sub ptap1 A=4e-12 P=8e-6
XM16_0 net4 vb3 net063 sub sg13_lv_nmos w=1u l=1u m=1
XT93 vss sub ptap1 A=4e-12 P=8e-6
XM16_1 net4 vb3 net063 sub sg13_lv_nmos w=1u l=1u m=1
XT94 vss sub ptap1 A=4e-12 P=8e-6
XM16_2 net4 vb3 net063 sub sg13_lv_nmos w=1u l=1u m=1
XT95 vss sub ptap1 A=4e-12 P=8e-6
XM16_3 net4 vb3 net063 sub sg13_lv_nmos w=1u l=1u m=1
XT96 vss sub ptap1 A=4e-12 P=8e-6
XM16_4 net4 vb3 net063 sub sg13_lv_nmos w=1u l=1u m=1
XT97 vss sub ptap1 A=4e-12 P=8e-6
XM16_5 net4 vb3 net063 sub sg13_lv_nmos w=1u l=1u m=1
XT98 vss sub ptap1 A=4e-12 P=8e-6
XM16_6 net4 vb3 net063 sub sg13_lv_nmos w=1u l=1u m=1
XT99 vss sub ptap1 A=4e-12 P=8e-6
XM16_7 net4 vb3 net063 sub sg13_lv_nmos w=1u l=1u m=1
XT100 vss sub ptap1 A=4e-12 P=8e-6
XM16_8 net4 vb3 net063 sub sg13_lv_nmos w=1u l=1u m=1
XT101 vss sub ptap1 A=4e-12 P=8e-6
XM16_9 net4 vb3 net063 sub sg13_lv_nmos w=1u l=1u m=1
XT102 vss sub ptap1 A=4e-12 P=8e-6
XM16_10 net4 vb3 net063 sub sg13_lv_nmos w=1u l=1u m=1
XT103 vss sub ptap1 A=4e-12 P=8e-6
XM16_11 net4 vb3 net063 sub sg13_lv_nmos w=1u l=1u m=1
XT104 vss sub ptap1 A=4e-12 P=8e-6
XM16_12 net4 vb3 net063 sub sg13_lv_nmos w=1u l=1u m=1
XT105 vss sub ptap1 A=4e-12 P=8e-6
XM16_13 net4 vb3 net063 sub sg13_lv_nmos w=1u l=1u m=1
XT106 vss sub ptap1 A=4e-12 P=8e-6
XM16_14 net4 vb3 net063 sub sg13_lv_nmos w=1u l=1u m=1
XT107 vss sub ptap1 A=4e-12 P=8e-6
XM16_15 net4 vb3 net063 sub sg13_lv_nmos w=1u l=1u m=1
XT108 vss sub ptap1 A=4e-12 P=8e-6
XM17_0 net54 vb4 vss sub sg13_lv_nmos w=1u l=1u m=1
XT109 vss sub ptap1 A=4e-12 P=8e-6
XM17_1 net54 vb4 vss sub sg13_lv_nmos w=1u l=1u m=1
XT110 vss sub ptap1 A=4e-12 P=8e-6
XM17_2 net54 vb4 vss sub sg13_lv_nmos w=1u l=1u m=1
XT111 vss sub ptap1 A=4e-12 P=8e-6
XM17_3 net54 vb4 vss sub sg13_lv_nmos w=1u l=1u m=1
XT112 vss sub ptap1 A=4e-12 P=8e-6
XM17_4 net54 vb4 vss sub sg13_lv_nmos w=1u l=1u m=1
XT113 vss sub ptap1 A=4e-12 P=8e-6
XM17_5 net54 vb4 vss sub sg13_lv_nmos w=1u l=1u m=1
XT114 vss sub ptap1 A=4e-12 P=8e-6
XM17_6 net54 vb4 vss sub sg13_lv_nmos w=1u l=1u m=1
XT115 vss sub ptap1 A=4e-12 P=8e-6
XM17_7 net54 vb4 vss sub sg13_lv_nmos w=1u l=1u m=1
XT116 vss sub ptap1 A=4e-12 P=8e-6
XM17_8 net54 vb4 vss sub sg13_lv_nmos w=1u l=1u m=1
XT117 vss sub ptap1 A=4e-12 P=8e-6
XM17_9 net54 vb4 vss sub sg13_lv_nmos w=1u l=1u m=1
XT118 vss sub ptap1 A=4e-12 P=8e-6
XM17_10 net54 vb4 vss sub sg13_lv_nmos w=1u l=1u m=1
XT119 vss sub ptap1 A=4e-12 P=8e-6
XM17_11 net54 vb4 vss sub sg13_lv_nmos w=1u l=1u m=1
XT120 vss sub ptap1 A=4e-12 P=8e-6
XM17_12 net54 vb4 vss sub sg13_lv_nmos w=1u l=1u m=1
XT121 vss sub ptap1 A=4e-12 P=8e-6
XM17_13 net54 vb4 vss sub sg13_lv_nmos w=1u l=1u m=1
XT122 vss sub ptap1 A=4e-12 P=8e-6
XM17_14 net54 vb4 vss sub sg13_lv_nmos w=1u l=1u m=1
XT123 vss sub ptap1 A=4e-12 P=8e-6
XM17_15 net54 vb4 vss sub sg13_lv_nmos w=1u l=1u m=1
XT124 vss sub ptap1 A=4e-12 P=8e-6
XM18_0 net56 vb4 vss sub sg13_lv_nmos w=1u l=1u m=1
XT125 vss sub ptap1 A=4e-12 P=8e-6
XM18_1 net56 vb4 vss sub sg13_lv_nmos w=1u l=1u m=1
XT126 vss sub ptap1 A=4e-12 P=8e-6
XM18_2 net56 vb4 vss sub sg13_lv_nmos w=1u l=1u m=1
XT127 vss sub ptap1 A=4e-12 P=8e-6
XM18_3 net56 vb4 vss sub sg13_lv_nmos w=1u l=1u m=1
XT128 vss sub ptap1 A=4e-12 P=8e-6
XM18_4 net56 vb4 vss sub sg13_lv_nmos w=1u l=1u m=1
XT129 vss sub ptap1 A=4e-12 P=8e-6
XM18_5 net56 vb4 vss sub sg13_lv_nmos w=1u l=1u m=1
XT130 vss sub ptap1 A=4e-12 P=8e-6
XM18_6 net56 vb4 vss sub sg13_lv_nmos w=1u l=1u m=1
XT131 vss sub ptap1 A=4e-12 P=8e-6
XM18_7 net56 vb4 vss sub sg13_lv_nmos w=1u l=1u m=1
XT132 vss sub ptap1 A=4e-12 P=8e-6
XM18_8 net56 vb4 vss sub sg13_lv_nmos w=1u l=1u m=1
XT133 vss sub ptap1 A=4e-12 P=8e-6
XM18_9 net56 vb4 vss sub sg13_lv_nmos w=1u l=1u m=1
XT134 vss sub ptap1 A=4e-12 P=8e-6
XM18_10 net56 vb4 vss sub sg13_lv_nmos w=1u l=1u m=1
XT135 vss sub ptap1 A=4e-12 P=8e-6
XM18_11 net56 vb4 vss sub sg13_lv_nmos w=1u l=1u m=1
XT136 vss sub ptap1 A=4e-12 P=8e-6
XM18_12 net56 vb4 vss sub sg13_lv_nmos w=1u l=1u m=1
XT137 vss sub ptap1 A=4e-12 P=8e-6
XM18_13 net56 vb4 vss sub sg13_lv_nmos w=1u l=1u m=1
XT138 vss sub ptap1 A=4e-12 P=8e-6
XM18_14 net56 vb4 vss sub sg13_lv_nmos w=1u l=1u m=1
XT139 vss sub ptap1 A=4e-12 P=8e-6
XM18_15 net56 vb4 vss sub sg13_lv_nmos w=1u l=1u m=1
XT140 vss sub ptap1 A=4e-12 P=8e-6
XM19_0 dm_2 vb4 vss sub sg13_lv_nmos w=1u l=1u m=1
XT141 vss sub ptap1 A=4e-12 P=8e-6
XM19_1 dm_2 vb4 vss sub sg13_lv_nmos w=1u l=1u m=1
XT142 vss sub ptap1 A=4e-12 P=8e-6
XM19_2 dm_2 vb4 vss sub sg13_lv_nmos w=1u l=1u m=1
XT143 vss sub ptap1 A=4e-12 P=8e-6
XM19_3 dm_2 vb4 vss sub sg13_lv_nmos w=1u l=1u m=1
XT144 vss sub ptap1 A=4e-12 P=8e-6
XM19_4 dm_2 vb4 vss sub sg13_lv_nmos w=1u l=1u m=1
XT145 vss sub ptap1 A=4e-12 P=8e-6
XM19_5 dm_2 vb4 vss sub sg13_lv_nmos w=1u l=1u m=1
XT146 vss sub ptap1 A=4e-12 P=8e-6
XM19_6 dm_2 vb4 vss sub sg13_lv_nmos w=1u l=1u m=1
XT147 vss sub ptap1 A=4e-12 P=8e-6
XM19_7 dm_2 vb4 vss sub sg13_lv_nmos w=1u l=1u m=1
XT148 vss sub ptap1 A=4e-12 P=8e-6
XM19_8 dm_2 vb4 vss sub sg13_lv_nmos w=1u l=1u m=1
XT149 vss sub ptap1 A=4e-12 P=8e-6
XM19_9 dm_2 vb4 vss sub sg13_lv_nmos w=1u l=1u m=1
XT150 vss sub ptap1 A=4e-12 P=8e-6
XM19_10 dm_2 vb4 vss sub sg13_lv_nmos w=1u l=1u m=1
XT151 vss sub ptap1 A=4e-12 P=8e-6
XM19_11 dm_2 vb4 vss sub sg13_lv_nmos w=1u l=1u m=1
XT152 vss sub ptap1 A=4e-12 P=8e-6
XM19_12 dm_2 vb4 vss sub sg13_lv_nmos w=1u l=1u m=1
XT153 vss sub ptap1 A=4e-12 P=8e-6
XM19_13 dm_2 vb4 vss sub sg13_lv_nmos w=1u l=1u m=1
XT154 vss sub ptap1 A=4e-12 P=8e-6
XM19_14 dm_2 vb4 vss sub sg13_lv_nmos w=1u l=1u m=1
XT155 vss sub ptap1 A=4e-12 P=8e-6
XM19_15 dm_2 vb4 vss sub sg13_lv_nmos w=1u l=1u m=1
XT156 vss sub ptap1 A=4e-12 P=8e-6
XM19_16 dm_2 vb4 vss sub sg13_lv_nmos w=1u l=1u m=1
XT157 vss sub ptap1 A=4e-12 P=8e-6
XM19_17 dm_2 vb4 vss sub sg13_lv_nmos w=1u l=1u m=1
XT158 vss sub ptap1 A=4e-12 P=8e-6
XM19_18 dm_2 vb4 vss sub sg13_lv_nmos w=1u l=1u m=1
XT159 vss sub ptap1 A=4e-12 P=8e-6
XM19_19 dm_2 vb4 vss sub sg13_lv_nmos w=1u l=1u m=1
XT160 vss sub ptap1 A=4e-12 P=8e-6
XM19_20 dm_2 vb4 vss sub sg13_lv_nmos w=1u l=1u m=1
XT161 vss sub ptap1 A=4e-12 P=8e-6
XM19_21 dm_2 vb4 vss sub sg13_lv_nmos w=1u l=1u m=1
XT162 vss sub ptap1 A=4e-12 P=8e-6
XM19_22 dm_2 vb4 vss sub sg13_lv_nmos w=1u l=1u m=1
XT163 vss sub ptap1 A=4e-12 P=8e-6
XM19_23 dm_2 vb4 vss sub sg13_lv_nmos w=1u l=1u m=1
XT164 vss sub ptap1 A=4e-12 P=8e-6
XM19_24 dm_2 vb4 vss sub sg13_lv_nmos w=1u l=1u m=1
XT165 vss sub ptap1 A=4e-12 P=8e-6
XM19_25 dm_2 vb4 vss sub sg13_lv_nmos w=1u l=1u m=1
XT166 vss sub ptap1 A=4e-12 P=8e-6
XM19_26 dm_2 vb4 vss sub sg13_lv_nmos w=1u l=1u m=1
XT167 vss sub ptap1 A=4e-12 P=8e-6
XM19_27 dm_2 vb4 vss sub sg13_lv_nmos w=1u l=1u m=1
XT168 vss sub ptap1 A=4e-12 P=8e-6
XM19_28 dm_2 vb4 vss sub sg13_lv_nmos w=1u l=1u m=1
XT169 vss sub ptap1 A=4e-12 P=8e-6
XM19_29 dm_2 vb4 vss sub sg13_lv_nmos w=1u l=1u m=1
XT170 vss sub ptap1 A=4e-12 P=8e-6
XM19_30 dm_2 vb4 vss sub sg13_lv_nmos w=1u l=1u m=1
XT171 vss sub ptap1 A=4e-12 P=8e-6
XM19_31 dm_2 vb4 vss sub sg13_lv_nmos w=1u l=1u m=1
XT172 vdd well_172 ntap1 A=4e-12 P=8e-6
XM2_0 dm_1 dm_1 vdd well_172 sg13_lv_pmos w=1u l=1u m=1
XT173 vdd well_173 ntap1 A=4e-12 P=8e-6
XM2_1 dm_1 dm_1 vdd well_173 sg13_lv_pmos w=1u l=1u m=1
XT174 vdd well_174 ntap1 A=4e-12 P=8e-6
XM2_2 dm_1 dm_1 vdd well_174 sg13_lv_pmos w=1u l=1u m=1
XT175 vdd well_175 ntap1 A=4e-12 P=8e-6
XM2_3 dm_1 dm_1 vdd well_175 sg13_lv_pmos w=1u l=1u m=1
XT176 vss sub ptap1 A=4e-12 P=8e-6
XM20_0 net063 vb4 vss sub sg13_lv_nmos w=1u l=1u m=1
XT177 vss sub ptap1 A=4e-12 P=8e-6
XM20_1 net063 vb4 vss sub sg13_lv_nmos w=1u l=1u m=1
XT178 vss sub ptap1 A=4e-12 P=8e-6
XM20_2 net063 vb4 vss sub sg13_lv_nmos w=1u l=1u m=1
XT179 vss sub ptap1 A=4e-12 P=8e-6
XM20_3 net063 vb4 vss sub sg13_lv_nmos w=1u l=1u m=1
XT180 vss sub ptap1 A=4e-12 P=8e-6
XM20_4 net063 vb4 vss sub sg13_lv_nmos w=1u l=1u m=1
XT181 vss sub ptap1 A=4e-12 P=8e-6
XM20_5 net063 vb4 vss sub sg13_lv_nmos w=1u l=1u m=1
XT182 vss sub ptap1 A=4e-12 P=8e-6
XM20_6 net063 vb4 vss sub sg13_lv_nmos w=1u l=1u m=1
XT183 vss sub ptap1 A=4e-12 P=8e-6
XM20_7 net063 vb4 vss sub sg13_lv_nmos w=1u l=1u m=1
XT184 vss sub ptap1 A=4e-12 P=8e-6
XM20_8 net063 vb4 vss sub sg13_lv_nmos w=1u l=1u m=1
XT185 vss sub ptap1 A=4e-12 P=8e-6
XM20_9 net063 vb4 vss sub sg13_lv_nmos w=1u l=1u m=1
XT186 vss sub ptap1 A=4e-12 P=8e-6
XM20_10 net063 vb4 vss sub sg13_lv_nmos w=1u l=1u m=1
XT187 vss sub ptap1 A=4e-12 P=8e-6
XM20_11 net063 vb4 vss sub sg13_lv_nmos w=1u l=1u m=1
XT188 vss sub ptap1 A=4e-12 P=8e-6
XM20_12 net063 vb4 vss sub sg13_lv_nmos w=1u l=1u m=1
XT189 vss sub ptap1 A=4e-12 P=8e-6
XM20_13 net063 vb4 vss sub sg13_lv_nmos w=1u l=1u m=1
XT190 vss sub ptap1 A=4e-12 P=8e-6
XM20_14 net063 vb4 vss sub sg13_lv_nmos w=1u l=1u m=1
XT191 vss sub ptap1 A=4e-12 P=8e-6
XM20_15 net063 vb4 vss sub sg13_lv_nmos w=1u l=1u m=1
XT192 vss sub ptap1 A=4e-12 P=8e-6
XM20_16 net063 vb4 vss sub sg13_lv_nmos w=1u l=1u m=1
XT193 vss sub ptap1 A=4e-12 P=8e-6
XM20_17 net063 vb4 vss sub sg13_lv_nmos w=1u l=1u m=1
XT194 vss sub ptap1 A=4e-12 P=8e-6
XM20_18 net063 vb4 vss sub sg13_lv_nmos w=1u l=1u m=1
XT195 vss sub ptap1 A=4e-12 P=8e-6
XM20_19 net063 vb4 vss sub sg13_lv_nmos w=1u l=1u m=1
XT196 vss sub ptap1 A=4e-12 P=8e-6
XM20_20 net063 vb4 vss sub sg13_lv_nmos w=1u l=1u m=1
XT197 vss sub ptap1 A=4e-12 P=8e-6
XM20_21 net063 vb4 vss sub sg13_lv_nmos w=1u l=1u m=1
XT198 vss sub ptap1 A=4e-12 P=8e-6
XM20_22 net063 vb4 vss sub sg13_lv_nmos w=1u l=1u m=1
XT199 vss sub ptap1 A=4e-12 P=8e-6
XM20_23 net063 vb4 vss sub sg13_lv_nmos w=1u l=1u m=1
XT200 vss sub ptap1 A=4e-12 P=8e-6
XM20_24 net063 vb4 vss sub sg13_lv_nmos w=1u l=1u m=1
XT201 vss sub ptap1 A=4e-12 P=8e-6
XM20_25 net063 vb4 vss sub sg13_lv_nmos w=1u l=1u m=1
XT202 vss sub ptap1 A=4e-12 P=8e-6
XM20_26 net063 vb4 vss sub sg13_lv_nmos w=1u l=1u m=1
XT203 vss sub ptap1 A=4e-12 P=8e-6
XM20_27 net063 vb4 vss sub sg13_lv_nmos w=1u l=1u m=1
XT204 vss sub ptap1 A=4e-12 P=8e-6
XM20_28 net063 vb4 vss sub sg13_lv_nmos w=1u l=1u m=1
XT205 vss sub ptap1 A=4e-12 P=8e-6
XM20_29 net063 vb4 vss sub sg13_lv_nmos w=1u l=1u m=1
XT206 vss sub ptap1 A=4e-12 P=8e-6
XM20_30 net063 vb4 vss sub sg13_lv_nmos w=1u l=1u m=1
XT207 vss sub ptap1 A=4e-12 P=8e-6
XM20_31 net063 vb4 vss sub sg13_lv_nmos w=1u l=1u m=1
XT208 vss sub ptap1 A=4e-12 P=8e-6
XM21_0 net043 net043 vss sub sg13_lv_nmos w=1u l=1u m=1
XT209 vss sub ptap1 A=4e-12 P=8e-6
XM21_1 net043 net043 vss sub sg13_lv_nmos w=1u l=1u m=1
XT210 vss sub ptap1 A=4e-12 P=8e-6
XM21_2 net043 net043 vss sub sg13_lv_nmos w=1u l=1u m=1
XT211 vss sub ptap1 A=4e-12 P=8e-6
XM21_3 net043 net043 vss sub sg13_lv_nmos w=1u l=1u m=1
XT212 vss sub ptap1 A=4e-12 P=8e-6
XM22_0 net049 net043 vss sub sg13_lv_nmos w=1u l=1u m=1
XT213 vss sub ptap1 A=4e-12 P=8e-6
XM22_1 net049 net043 vss sub sg13_lv_nmos w=1u l=1u m=1
XT214 vss sub ptap1 A=4e-12 P=8e-6
XM22_2 net049 net043 vss sub sg13_lv_nmos w=1u l=1u m=1
XT215 vss sub ptap1 A=4e-12 P=8e-6
XM22_3 net049 net043 vss sub sg13_lv_nmos w=1u l=1u m=1
XT216 vss sub ptap1 A=4e-12 P=8e-6
XM23_0 vout net049 vss sub sg13_lv_nmos w=1u l=1u m=1
XT217 vss sub ptap1 A=4e-12 P=8e-6
XM23_1 vout net049 vss sub sg13_lv_nmos w=1u l=1u m=1
XT218 vss sub ptap1 A=4e-12 P=8e-6
XM23_2 vout net049 vss sub sg13_lv_nmos w=1u l=1u m=1
XT219 vss sub ptap1 A=4e-12 P=8e-6
XM23_3 vout net049 vss sub sg13_lv_nmos w=1u l=1u m=1
XT220 vdd well_220 ntap1 A=4e-12 P=8e-6
XM3_0 vb3 net013 vdd well_220 sg13_lv_pmos w=1u l=1u m=1
XT221 vdd well_221 ntap1 A=4e-12 P=8e-6
XM3_1 vb3 net013 vdd well_221 sg13_lv_pmos w=1u l=1u m=1
XT222 vdd well_222 ntap1 A=4e-12 P=8e-6
XM3_2 vb3 net013 vdd well_222 sg13_lv_pmos w=1u l=1u m=1
XT223 vdd well_223 ntap1 A=4e-12 P=8e-6
XM3_3 vb3 net013 vdd well_223 sg13_lv_pmos w=1u l=1u m=1
XT224 vdd well_224 ntap1 A=4e-12 P=8e-6
XM3_4 vb3 net013 vdd well_224 sg13_lv_pmos w=1u l=1u m=1
XT225 vdd well_225 ntap1 A=4e-12 P=8e-6
XM3_5 vb3 net013 vdd well_225 sg13_lv_pmos w=1u l=1u m=1
XT226 vdd well_226 ntap1 A=4e-12 P=8e-6
XM3_6 vb3 net013 vdd well_226 sg13_lv_pmos w=1u l=1u m=1
XT227 vdd well_227 ntap1 A=4e-12 P=8e-6
XM3_7 vb3 net013 vdd well_227 sg13_lv_pmos w=1u l=1u m=1
XT228 vdd well_228 ntap1 A=4e-12 P=8e-6
XM3_8 vb3 net013 vdd well_228 sg13_lv_pmos w=1u l=1u m=1
XT229 vdd well_229 ntap1 A=4e-12 P=8e-6
XM3_9 vb3 net013 vdd well_229 sg13_lv_pmos w=1u l=1u m=1
XT230 vdd well_230 ntap1 A=4e-12 P=8e-6
XM3_10 vb3 net013 vdd well_230 sg13_lv_pmos w=1u l=1u m=1
XT231 vdd well_231 ntap1 A=4e-12 P=8e-6
XM3_11 vb3 net013 vdd well_231 sg13_lv_pmos w=1u l=1u m=1
XT232 vdd well_232 ntap1 A=4e-12 P=8e-6
XM3_12 vb3 net013 vdd well_232 sg13_lv_pmos w=1u l=1u m=1
XT233 vdd well_233 ntap1 A=4e-12 P=8e-6
XM3_13 vb3 net013 vdd well_233 sg13_lv_pmos w=1u l=1u m=1
XT234 vdd well_234 ntap1 A=4e-12 P=8e-6
XM3_14 vb3 net013 vdd well_234 sg13_lv_pmos w=1u l=1u m=1
XT235 vdd well_235 ntap1 A=4e-12 P=8e-6
XM3_15 vb3 net013 vdd well_235 sg13_lv_pmos w=1u l=1u m=1
XT236 vdd well_236 ntap1 A=4e-12 P=8e-6
XM4_0 net31 net013 vdd well_236 sg13_lv_pmos w=1u l=1u m=1
XT237 vdd well_237 ntap1 A=4e-12 P=8e-6
XM4_1 net31 net013 vdd well_237 sg13_lv_pmos w=1u l=1u m=1
XT238 vdd well_238 ntap1 A=4e-12 P=8e-6
XM4_2 net31 net013 vdd well_238 sg13_lv_pmos w=1u l=1u m=1
XT239 vdd well_239 ntap1 A=4e-12 P=8e-6
XM4_3 net31 net013 vdd well_239 sg13_lv_pmos w=1u l=1u m=1
XT240 vdd well_240 ntap1 A=4e-12 P=8e-6
XM4_4 net31 net013 vdd well_240 sg13_lv_pmos w=1u l=1u m=1
XT241 vdd well_241 ntap1 A=4e-12 P=8e-6
XM4_5 net31 net013 vdd well_241 sg13_lv_pmos w=1u l=1u m=1
XT242 vdd well_242 ntap1 A=4e-12 P=8e-6
XM4_6 net31 net013 vdd well_242 sg13_lv_pmos w=1u l=1u m=1
XT243 vdd well_243 ntap1 A=4e-12 P=8e-6
XM4_7 net31 net013 vdd well_243 sg13_lv_pmos w=1u l=1u m=1
XT244 vdd well_244 ntap1 A=4e-12 P=8e-6
XM5_0 net5 voutn vdd well_244 sg13_lv_pmos w=1u l=1u m=1
XT245 vdd well_245 ntap1 A=4e-12 P=8e-6
XM5_1 net5 voutn vdd well_245 sg13_lv_pmos w=1u l=1u m=1
XT246 vdd well_246 ntap1 A=4e-12 P=8e-6
XM5_2 net5 voutn vdd well_246 sg13_lv_pmos w=1u l=1u m=1
XT247 vdd well_247 ntap1 A=4e-12 P=8e-6
XM5_3 net5 voutn vdd well_247 sg13_lv_pmos w=1u l=1u m=1
XT248 net1 well_248 ntap1 A=4e-12 P=8e-6
XM57_0 net043 vinn net1 well_248 sg13_lv_pmos w=1u l=1u m=1
XT249 net1 well_249 ntap1 A=4e-12 P=8e-6
XM57_1 net043 vinn net1 well_249 sg13_lv_pmos w=1u l=1u m=1
XT250 net1 well_250 ntap1 A=4e-12 P=8e-6
XM57_2 net043 vinn net1 well_250 sg13_lv_pmos w=1u l=1u m=1
XT251 net1 well_251 ntap1 A=4e-12 P=8e-6
XM57_3 net043 vinn net1 well_251 sg13_lv_pmos w=1u l=1u m=1
XT252 net1 well_252 ntap1 A=4e-12 P=8e-6
XM58_0 net049 vinp net1 well_252 sg13_lv_pmos w=1u l=1u m=1
XT253 net1 well_253 ntap1 A=4e-12 P=8e-6
XM58_1 net049 vinp net1 well_253 sg13_lv_pmos w=1u l=1u m=1
XT254 net1 well_254 ntap1 A=4e-12 P=8e-6
XM58_2 net049 vinp net1 well_254 sg13_lv_pmos w=1u l=1u m=1
XT255 net1 well_255 ntap1 A=4e-12 P=8e-6
XM58_3 net049 vinp net1 well_255 sg13_lv_pmos w=1u l=1u m=1
XT256 vdd well_256 ntap1 A=4e-12 P=8e-6
XM59_0 net1 net013 vdd well_256 sg13_lv_pmos w=1u l=1u m=1
XT257 vdd well_257 ntap1 A=4e-12 P=8e-6
XM59_1 net1 net013 vdd well_257 sg13_lv_pmos w=1u l=1u m=1
XT258 vdd well_258 ntap1 A=4e-12 P=8e-6
XM59_2 net1 net013 vdd well_258 sg13_lv_pmos w=1u l=1u m=1
XT259 vdd well_259 ntap1 A=4e-12 P=8e-6
XM59_3 net1 net013 vdd well_259 sg13_lv_pmos w=1u l=1u m=1
XT260 vdd well_260 ntap1 A=4e-12 P=8e-6
XM59_4 net1 net013 vdd well_260 sg13_lv_pmos w=1u l=1u m=1
XT261 vdd well_261 ntap1 A=4e-12 P=8e-6
XM59_5 net1 net013 vdd well_261 sg13_lv_pmos w=1u l=1u m=1
XT262 vdd well_262 ntap1 A=4e-12 P=8e-6
XM59_6 net1 net013 vdd well_262 sg13_lv_pmos w=1u l=1u m=1
XT263 vdd well_263 ntap1 A=4e-12 P=8e-6
XM59_7 net1 net013 vdd well_263 sg13_lv_pmos w=1u l=1u m=1
XT264 vdd well_264 ntap1 A=4e-12 P=8e-6
XM6_0 net050 voutn vdd well_264 sg13_lv_pmos w=1u l=1u m=1
XT265 vdd well_265 ntap1 A=4e-12 P=8e-6
XM6_1 net050 voutn vdd well_265 sg13_lv_pmos w=1u l=1u m=1
XT266 vdd well_266 ntap1 A=4e-12 P=8e-6
XM6_2 net050 voutn vdd well_266 sg13_lv_pmos w=1u l=1u m=1
XT267 vdd well_267 ntap1 A=4e-12 P=8e-6
XM6_3 net050 voutn vdd well_267 sg13_lv_pmos w=1u l=1u m=1
XT268 vdd well_268 ntap1 A=4e-12 P=8e-6
XM60_0 voutn dm_1 net5 well_268 sg13_lv_pmos w=1u l=1u m=1
XT269 vdd well_269 ntap1 A=4e-12 P=8e-6
XM60_1 voutn dm_1 net5 well_269 sg13_lv_pmos w=1u l=1u m=1
XT270 vdd well_270 ntap1 A=4e-12 P=8e-6
XM60_2 voutn dm_1 net5 well_270 sg13_lv_pmos w=1u l=1u m=1
XT271 vdd well_271 ntap1 A=4e-12 P=8e-6
XM60_3 voutn dm_1 net5 well_271 sg13_lv_pmos w=1u l=1u m=1
XT272 vdd well_272 ntap1 A=4e-12 P=8e-6
XM60_4 voutn dm_1 net5 well_272 sg13_lv_pmos w=1u l=1u m=1
XT273 vdd well_273 ntap1 A=4e-12 P=8e-6
XM60_5 voutn dm_1 net5 well_273 sg13_lv_pmos w=1u l=1u m=1
XT274 vdd well_274 ntap1 A=4e-12 P=8e-6
XM60_6 voutn dm_1 net5 well_274 sg13_lv_pmos w=1u l=1u m=1
XT275 vdd well_275 ntap1 A=4e-12 P=8e-6
XM60_7 voutn dm_1 net5 well_275 sg13_lv_pmos w=1u l=1u m=1
XT276 vdd well_276 ntap1 A=4e-12 P=8e-6
XM60_8 voutn dm_1 net5 well_276 sg13_lv_pmos w=1u l=1u m=1
XT277 vdd well_277 ntap1 A=4e-12 P=8e-6
XM60_9 voutn dm_1 net5 well_277 sg13_lv_pmos w=1u l=1u m=1
XT278 vdd well_278 ntap1 A=4e-12 P=8e-6
XM60_10 voutn dm_1 net5 well_278 sg13_lv_pmos w=1u l=1u m=1
XT279 vdd well_279 ntap1 A=4e-12 P=8e-6
XM60_11 voutn dm_1 net5 well_279 sg13_lv_pmos w=1u l=1u m=1
XT280 vdd well_280 ntap1 A=4e-12 P=8e-6
XM60_12 voutn dm_1 net5 well_280 sg13_lv_pmos w=1u l=1u m=1
XT281 vdd well_281 ntap1 A=4e-12 P=8e-6
XM60_13 voutn dm_1 net5 well_281 sg13_lv_pmos w=1u l=1u m=1
XT282 vdd well_282 ntap1 A=4e-12 P=8e-6
XM60_14 voutn dm_1 net5 well_282 sg13_lv_pmos w=1u l=1u m=1
XT283 vdd well_283 ntap1 A=4e-12 P=8e-6
XM60_15 voutn dm_1 net5 well_283 sg13_lv_pmos w=1u l=1u m=1
XT284 vdd well_284 ntap1 A=4e-12 P=8e-6
XM61_0 net4 dm_1 net050 well_284 sg13_lv_pmos w=1u l=1u m=1
XT285 vdd well_285 ntap1 A=4e-12 P=8e-6
XM61_1 net4 dm_1 net050 well_285 sg13_lv_pmos w=1u l=1u m=1
XT286 vdd well_286 ntap1 A=4e-12 P=8e-6
XM61_2 net4 dm_1 net050 well_286 sg13_lv_pmos w=1u l=1u m=1
XT287 vdd well_287 ntap1 A=4e-12 P=8e-6
XM61_3 net4 dm_1 net050 well_287 sg13_lv_pmos w=1u l=1u m=1
XT288 vdd well_288 ntap1 A=4e-12 P=8e-6
XM61_4 net4 dm_1 net050 well_288 sg13_lv_pmos w=1u l=1u m=1
XT289 vdd well_289 ntap1 A=4e-12 P=8e-6
XM61_5 net4 dm_1 net050 well_289 sg13_lv_pmos w=1u l=1u m=1
XT290 vdd well_290 ntap1 A=4e-12 P=8e-6
XM61_6 net4 dm_1 net050 well_290 sg13_lv_pmos w=1u l=1u m=1
XT291 vdd well_291 ntap1 A=4e-12 P=8e-6
XM61_7 net4 dm_1 net050 well_291 sg13_lv_pmos w=1u l=1u m=1
XT292 vdd well_292 ntap1 A=4e-12 P=8e-6
XM61_8 net4 dm_1 net050 well_292 sg13_lv_pmos w=1u l=1u m=1
XT293 vdd well_293 ntap1 A=4e-12 P=8e-6
XM61_9 net4 dm_1 net050 well_293 sg13_lv_pmos w=1u l=1u m=1
XT294 vdd well_294 ntap1 A=4e-12 P=8e-6
XM61_10 net4 dm_1 net050 well_294 sg13_lv_pmos w=1u l=1u m=1
XT295 vdd well_295 ntap1 A=4e-12 P=8e-6
XM61_11 net4 dm_1 net050 well_295 sg13_lv_pmos w=1u l=1u m=1
XT296 vdd well_296 ntap1 A=4e-12 P=8e-6
XM61_12 net4 dm_1 net050 well_296 sg13_lv_pmos w=1u l=1u m=1
XT297 vdd well_297 ntap1 A=4e-12 P=8e-6
XM61_13 net4 dm_1 net050 well_297 sg13_lv_pmos w=1u l=1u m=1
XT298 vdd well_298 ntap1 A=4e-12 P=8e-6
XM61_14 net4 dm_1 net050 well_298 sg13_lv_pmos w=1u l=1u m=1
XT299 vdd well_299 ntap1 A=4e-12 P=8e-6
XM61_15 net4 dm_1 net050 well_299 sg13_lv_pmos w=1u l=1u m=1
XT300 vdd well_300 ntap1 A=4e-12 P=8e-6
XM62_0 voutn dm_1 net3 well_300 sg13_lv_pmos w=1u l=1u m=1
XT301 vdd well_301 ntap1 A=4e-12 P=8e-6
XM62_1 voutn dm_1 net3 well_301 sg13_lv_pmos w=1u l=1u m=1
XT302 vdd well_302 ntap1 A=4e-12 P=8e-6
XM62_2 voutn dm_1 net3 well_302 sg13_lv_pmos w=1u l=1u m=1
XT303 vdd well_303 ntap1 A=4e-12 P=8e-6
XM62_3 voutn dm_1 net3 well_303 sg13_lv_pmos w=1u l=1u m=1
XT304 vdd well_304 ntap1 A=4e-12 P=8e-6
XM62_4 voutn dm_1 net3 well_304 sg13_lv_pmos w=1u l=1u m=1
XT305 vdd well_305 ntap1 A=4e-12 P=8e-6
XM62_5 voutn dm_1 net3 well_305 sg13_lv_pmos w=1u l=1u m=1
XT306 vdd well_306 ntap1 A=4e-12 P=8e-6
XM62_6 voutn dm_1 net3 well_306 sg13_lv_pmos w=1u l=1u m=1
XT307 vdd well_307 ntap1 A=4e-12 P=8e-6
XM62_7 voutn dm_1 net3 well_307 sg13_lv_pmos w=1u l=1u m=1
XT308 vdd well_308 ntap1 A=4e-12 P=8e-6
XM62_8 voutn dm_1 net3 well_308 sg13_lv_pmos w=1u l=1u m=1
XT309 vdd well_309 ntap1 A=4e-12 P=8e-6
XM62_9 voutn dm_1 net3 well_309 sg13_lv_pmos w=1u l=1u m=1
XT310 vdd well_310 ntap1 A=4e-12 P=8e-6
XM62_10 voutn dm_1 net3 well_310 sg13_lv_pmos w=1u l=1u m=1
XT311 vdd well_311 ntap1 A=4e-12 P=8e-6
XM62_11 voutn dm_1 net3 well_311 sg13_lv_pmos w=1u l=1u m=1
XT312 vdd well_312 ntap1 A=4e-12 P=8e-6
XM62_12 voutn dm_1 net3 well_312 sg13_lv_pmos w=1u l=1u m=1
XT313 vdd well_313 ntap1 A=4e-12 P=8e-6
XM62_13 voutn dm_1 net3 well_313 sg13_lv_pmos w=1u l=1u m=1
XT314 vdd well_314 ntap1 A=4e-12 P=8e-6
XM62_14 voutn dm_1 net3 well_314 sg13_lv_pmos w=1u l=1u m=1
XT315 vdd well_315 ntap1 A=4e-12 P=8e-6
XM62_15 voutn dm_1 net3 well_315 sg13_lv_pmos w=1u l=1u m=1
XT316 vdd well_316 ntap1 A=4e-12 P=8e-6
XM63_0 net70 dm_1 net2 well_316 sg13_lv_pmos w=1u l=1u m=1
XT317 vdd well_317 ntap1 A=4e-12 P=8e-6
XM63_1 net70 dm_1 net2 well_317 sg13_lv_pmos w=1u l=1u m=1
XT318 vdd well_318 ntap1 A=4e-12 P=8e-6
XM63_2 net70 dm_1 net2 well_318 sg13_lv_pmos w=1u l=1u m=1
XT319 vdd well_319 ntap1 A=4e-12 P=8e-6
XM63_3 net70 dm_1 net2 well_319 sg13_lv_pmos w=1u l=1u m=1
XT320 vdd well_320 ntap1 A=4e-12 P=8e-6
XM63_4 net70 dm_1 net2 well_320 sg13_lv_pmos w=1u l=1u m=1
XT321 vdd well_321 ntap1 A=4e-12 P=8e-6
XM63_5 net70 dm_1 net2 well_321 sg13_lv_pmos w=1u l=1u m=1
XT322 vdd well_322 ntap1 A=4e-12 P=8e-6
XM63_6 net70 dm_1 net2 well_322 sg13_lv_pmos w=1u l=1u m=1
XT323 vdd well_323 ntap1 A=4e-12 P=8e-6
XM63_7 net70 dm_1 net2 well_323 sg13_lv_pmos w=1u l=1u m=1
XT324 vdd well_324 ntap1 A=4e-12 P=8e-6
XM63_8 net70 dm_1 net2 well_324 sg13_lv_pmos w=1u l=1u m=1
XT325 vdd well_325 ntap1 A=4e-12 P=8e-6
XM63_9 net70 dm_1 net2 well_325 sg13_lv_pmos w=1u l=1u m=1
XT326 vdd well_326 ntap1 A=4e-12 P=8e-6
XM63_10 net70 dm_1 net2 well_326 sg13_lv_pmos w=1u l=1u m=1
XT327 vdd well_327 ntap1 A=4e-12 P=8e-6
XM63_11 net70 dm_1 net2 well_327 sg13_lv_pmos w=1u l=1u m=1
XT328 vdd well_328 ntap1 A=4e-12 P=8e-6
XM63_12 net70 dm_1 net2 well_328 sg13_lv_pmos w=1u l=1u m=1
XT329 vdd well_329 ntap1 A=4e-12 P=8e-6
XM63_13 net70 dm_1 net2 well_329 sg13_lv_pmos w=1u l=1u m=1
XT330 vdd well_330 ntap1 A=4e-12 P=8e-6
XM63_14 net70 dm_1 net2 well_330 sg13_lv_pmos w=1u l=1u m=1
XT331 vdd well_331 ntap1 A=4e-12 P=8e-6
XM63_15 net70 dm_1 net2 well_331 sg13_lv_pmos w=1u l=1u m=1
XT332 vss sub ptap1 A=4e-12 P=8e-6
XM64_0 net85 vb4 vss sub sg13_lv_nmos w=1u l=1u m=1
XT333 vss sub ptap1 A=4e-12 P=8e-6
XM64_1 net85 vb4 vss sub sg13_lv_nmos w=1u l=1u m=1
XT334 vss sub ptap1 A=4e-12 P=8e-6
XM64_2 net85 vb4 vss sub sg13_lv_nmos w=1u l=1u m=1
XT335 vss sub ptap1 A=4e-12 P=8e-6
XM64_3 net85 vb4 vss sub sg13_lv_nmos w=1u l=1u m=1
XT336 vss sub ptap1 A=4e-12 P=8e-6
XM64_4 net85 vb4 vss sub sg13_lv_nmos w=1u l=1u m=1
XT337 vss sub ptap1 A=4e-12 P=8e-6
XM64_5 net85 vb4 vss sub sg13_lv_nmos w=1u l=1u m=1
XT338 vss sub ptap1 A=4e-12 P=8e-6
XM64_6 net85 vb4 vss sub sg13_lv_nmos w=1u l=1u m=1
XT339 vss sub ptap1 A=4e-12 P=8e-6
XM64_7 net85 vb4 vss sub sg13_lv_nmos w=1u l=1u m=1
XT340 vss sub ptap1 A=4e-12 P=8e-6
XM64_8 net85 vb4 vss sub sg13_lv_nmos w=1u l=1u m=1
XT341 vss sub ptap1 A=4e-12 P=8e-6
XM64_9 net85 vb4 vss sub sg13_lv_nmos w=1u l=1u m=1
XT342 vss sub ptap1 A=4e-12 P=8e-6
XM64_10 net85 vb4 vss sub sg13_lv_nmos w=1u l=1u m=1
XT343 vss sub ptap1 A=4e-12 P=8e-6
XM64_11 net85 vb4 vss sub sg13_lv_nmos w=1u l=1u m=1
XT344 vss sub ptap1 A=4e-12 P=8e-6
XM64_12 net85 vb4 vss sub sg13_lv_nmos w=1u l=1u m=1
XT345 vss sub ptap1 A=4e-12 P=8e-6
XM64_13 net85 vb4 vss sub sg13_lv_nmos w=1u l=1u m=1
XT346 vss sub ptap1 A=4e-12 P=8e-6
XM64_14 net85 vb4 vss sub sg13_lv_nmos w=1u l=1u m=1
XT347 vss sub ptap1 A=4e-12 P=8e-6
XM64_15 net85 vb4 vss sub sg13_lv_nmos w=1u l=1u m=1
XT348 vss sub ptap1 A=4e-12 P=8e-6
XM64_16 net85 vb4 vss sub sg13_lv_nmos w=1u l=1u m=1
XT349 vss sub ptap1 A=4e-12 P=8e-6
XM64_17 net85 vb4 vss sub sg13_lv_nmos w=1u l=1u m=1
XT350 vss sub ptap1 A=4e-12 P=8e-6
XM64_18 net85 vb4 vss sub sg13_lv_nmos w=1u l=1u m=1
XT351 vss sub ptap1 A=4e-12 P=8e-6
XM64_19 net85 vb4 vss sub sg13_lv_nmos w=1u l=1u m=1
XT352 vss sub ptap1 A=4e-12 P=8e-6
XM64_20 net85 vb4 vss sub sg13_lv_nmos w=1u l=1u m=1
XT353 vss sub ptap1 A=4e-12 P=8e-6
XM64_21 net85 vb4 vss sub sg13_lv_nmos w=1u l=1u m=1
XT354 vss sub ptap1 A=4e-12 P=8e-6
XM64_22 net85 vb4 vss sub sg13_lv_nmos w=1u l=1u m=1
XT355 vss sub ptap1 A=4e-12 P=8e-6
XM64_23 net85 vb4 vss sub sg13_lv_nmos w=1u l=1u m=1
XT356 vss sub ptap1 A=4e-12 P=8e-6
XM64_24 net85 vb4 vss sub sg13_lv_nmos w=1u l=1u m=1
XT357 vss sub ptap1 A=4e-12 P=8e-6
XM64_25 net85 vb4 vss sub sg13_lv_nmos w=1u l=1u m=1
XT358 vss sub ptap1 A=4e-12 P=8e-6
XM64_26 net85 vb4 vss sub sg13_lv_nmos w=1u l=1u m=1
XT359 vss sub ptap1 A=4e-12 P=8e-6
XM64_27 net85 vb4 vss sub sg13_lv_nmos w=1u l=1u m=1
XT360 vss sub ptap1 A=4e-12 P=8e-6
XM64_28 net85 vb4 vss sub sg13_lv_nmos w=1u l=1u m=1
XT361 vss sub ptap1 A=4e-12 P=8e-6
XM64_29 net85 vb4 vss sub sg13_lv_nmos w=1u l=1u m=1
XT362 vss sub ptap1 A=4e-12 P=8e-6
XM64_30 net85 vb4 vss sub sg13_lv_nmos w=1u l=1u m=1
XT363 vss sub ptap1 A=4e-12 P=8e-6
XM64_31 net85 vb4 vss sub sg13_lv_nmos w=1u l=1u m=1
XT364 vss sub ptap1 A=4e-12 P=8e-6
XM65_0 net69 vb4 vss sub sg13_lv_nmos w=1u l=1u m=1
XT365 vss sub ptap1 A=4e-12 P=8e-6
XM65_1 net69 vb4 vss sub sg13_lv_nmos w=1u l=1u m=1
XT366 vss sub ptap1 A=4e-12 P=8e-6
XM65_2 net69 vb4 vss sub sg13_lv_nmos w=1u l=1u m=1
XT367 vss sub ptap1 A=4e-12 P=8e-6
XM65_3 net69 vb4 vss sub sg13_lv_nmos w=1u l=1u m=1
XT368 vss sub ptap1 A=4e-12 P=8e-6
XM65_4 net69 vb4 vss sub sg13_lv_nmos w=1u l=1u m=1
XT369 vss sub ptap1 A=4e-12 P=8e-6
XM65_5 net69 vb4 vss sub sg13_lv_nmos w=1u l=1u m=1
XT370 vss sub ptap1 A=4e-12 P=8e-6
XM65_6 net69 vb4 vss sub sg13_lv_nmos w=1u l=1u m=1
XT371 vss sub ptap1 A=4e-12 P=8e-6
XM65_7 net69 vb4 vss sub sg13_lv_nmos w=1u l=1u m=1
XT372 vss sub ptap1 A=4e-12 P=8e-6
XM65_8 net69 vb4 vss sub sg13_lv_nmos w=1u l=1u m=1
XT373 vss sub ptap1 A=4e-12 P=8e-6
XM65_9 net69 vb4 vss sub sg13_lv_nmos w=1u l=1u m=1
XT374 vss sub ptap1 A=4e-12 P=8e-6
XM65_10 net69 vb4 vss sub sg13_lv_nmos w=1u l=1u m=1
XT375 vss sub ptap1 A=4e-12 P=8e-6
XM65_11 net69 vb4 vss sub sg13_lv_nmos w=1u l=1u m=1
XT376 vss sub ptap1 A=4e-12 P=8e-6
XM65_12 net69 vb4 vss sub sg13_lv_nmos w=1u l=1u m=1
XT377 vss sub ptap1 A=4e-12 P=8e-6
XM65_13 net69 vb4 vss sub sg13_lv_nmos w=1u l=1u m=1
XT378 vss sub ptap1 A=4e-12 P=8e-6
XM65_14 net69 vb4 vss sub sg13_lv_nmos w=1u l=1u m=1
XT379 vss sub ptap1 A=4e-12 P=8e-6
XM65_15 net69 vb4 vss sub sg13_lv_nmos w=1u l=1u m=1
XT380 vss sub ptap1 A=4e-12 P=8e-6
XM65_16 net69 vb4 vss sub sg13_lv_nmos w=1u l=1u m=1
XT381 vss sub ptap1 A=4e-12 P=8e-6
XM65_17 net69 vb4 vss sub sg13_lv_nmos w=1u l=1u m=1
XT382 vss sub ptap1 A=4e-12 P=8e-6
XM65_18 net69 vb4 vss sub sg13_lv_nmos w=1u l=1u m=1
XT383 vss sub ptap1 A=4e-12 P=8e-6
XM65_19 net69 vb4 vss sub sg13_lv_nmos w=1u l=1u m=1
XT384 vss sub ptap1 A=4e-12 P=8e-6
XM65_20 net69 vb4 vss sub sg13_lv_nmos w=1u l=1u m=1
XT385 vss sub ptap1 A=4e-12 P=8e-6
XM65_21 net69 vb4 vss sub sg13_lv_nmos w=1u l=1u m=1
XT386 vss sub ptap1 A=4e-12 P=8e-6
XM65_22 net69 vb4 vss sub sg13_lv_nmos w=1u l=1u m=1
XT387 vss sub ptap1 A=4e-12 P=8e-6
XM65_23 net69 vb4 vss sub sg13_lv_nmos w=1u l=1u m=1
XT388 vss sub ptap1 A=4e-12 P=8e-6
XM65_24 net69 vb4 vss sub sg13_lv_nmos w=1u l=1u m=1
XT389 vss sub ptap1 A=4e-12 P=8e-6
XM65_25 net69 vb4 vss sub sg13_lv_nmos w=1u l=1u m=1
XT390 vss sub ptap1 A=4e-12 P=8e-6
XM65_26 net69 vb4 vss sub sg13_lv_nmos w=1u l=1u m=1
XT391 vss sub ptap1 A=4e-12 P=8e-6
XM65_27 net69 vb4 vss sub sg13_lv_nmos w=1u l=1u m=1
XT392 vss sub ptap1 A=4e-12 P=8e-6
XM65_28 net69 vb4 vss sub sg13_lv_nmos w=1u l=1u m=1
XT393 vss sub ptap1 A=4e-12 P=8e-6
XM65_29 net69 vb4 vss sub sg13_lv_nmos w=1u l=1u m=1
XT394 vss sub ptap1 A=4e-12 P=8e-6
XM65_30 net69 vb4 vss sub sg13_lv_nmos w=1u l=1u m=1
XT395 vss sub ptap1 A=4e-12 P=8e-6
XM65_31 net69 vb4 vss sub sg13_lv_nmos w=1u l=1u m=1
XT396 vdd well_396 ntap1 A=4e-12 P=8e-6
XM68_0 net2 net70 vdd well_396 sg13_lv_pmos w=1u l=1u m=1
XT397 vdd well_397 ntap1 A=4e-12 P=8e-6
XM68_1 net2 net70 vdd well_397 sg13_lv_pmos w=1u l=1u m=1
XT398 vdd well_398 ntap1 A=4e-12 P=8e-6
XM68_2 net2 net70 vdd well_398 sg13_lv_pmos w=1u l=1u m=1
XT399 vdd well_399 ntap1 A=4e-12 P=8e-6
XM68_3 net2 net70 vdd well_399 sg13_lv_pmos w=1u l=1u m=1
XT400 vdd well_400 ntap1 A=4e-12 P=8e-6
XM68_4 net2 net70 vdd well_400 sg13_lv_pmos w=1u l=1u m=1
XT401 vdd well_401 ntap1 A=4e-12 P=8e-6
XM68_5 net2 net70 vdd well_401 sg13_lv_pmos w=1u l=1u m=1
XT402 vdd well_402 ntap1 A=4e-12 P=8e-6
XM68_6 net2 net70 vdd well_402 sg13_lv_pmos w=1u l=1u m=1
XT403 vdd well_403 ntap1 A=4e-12 P=8e-6
XM68_7 net2 net70 vdd well_403 sg13_lv_pmos w=1u l=1u m=1
XT404 vdd well_404 ntap1 A=4e-12 P=8e-6
XM68_8 net2 net70 vdd well_404 sg13_lv_pmos w=1u l=1u m=1
XT405 vdd well_405 ntap1 A=4e-12 P=8e-6
XM68_9 net2 net70 vdd well_405 sg13_lv_pmos w=1u l=1u m=1
XT406 vdd well_406 ntap1 A=4e-12 P=8e-6
XM68_10 net2 net70 vdd well_406 sg13_lv_pmos w=1u l=1u m=1
XT407 vdd well_407 ntap1 A=4e-12 P=8e-6
XM68_11 net2 net70 vdd well_407 sg13_lv_pmos w=1u l=1u m=1
XT408 vdd well_408 ntap1 A=4e-12 P=8e-6
XM68_12 net2 net70 vdd well_408 sg13_lv_pmos w=1u l=1u m=1
XT409 vdd well_409 ntap1 A=4e-12 P=8e-6
XM68_13 net2 net70 vdd well_409 sg13_lv_pmos w=1u l=1u m=1
XT410 vdd well_410 ntap1 A=4e-12 P=8e-6
XM68_14 net2 net70 vdd well_410 sg13_lv_pmos w=1u l=1u m=1
XT411 vdd well_411 ntap1 A=4e-12 P=8e-6
XM68_15 net2 net70 vdd well_411 sg13_lv_pmos w=1u l=1u m=1
XT412 vdd well_412 ntap1 A=4e-12 P=8e-6
XM69_0 net3 net70 vdd well_412 sg13_lv_pmos w=1u l=1u m=1
XT413 vdd well_413 ntap1 A=4e-12 P=8e-6
XM69_1 net3 net70 vdd well_413 sg13_lv_pmos w=1u l=1u m=1
XT414 vdd well_414 ntap1 A=4e-12 P=8e-6
XM69_2 net3 net70 vdd well_414 sg13_lv_pmos w=1u l=1u m=1
XT415 vdd well_415 ntap1 A=4e-12 P=8e-6
XM69_3 net3 net70 vdd well_415 sg13_lv_pmos w=1u l=1u m=1
XT416 vdd well_416 ntap1 A=4e-12 P=8e-6
XM69_4 net3 net70 vdd well_416 sg13_lv_pmos w=1u l=1u m=1
XT417 vdd well_417 ntap1 A=4e-12 P=8e-6
XM69_5 net3 net70 vdd well_417 sg13_lv_pmos w=1u l=1u m=1
XT418 vdd well_418 ntap1 A=4e-12 P=8e-6
XM69_6 net3 net70 vdd well_418 sg13_lv_pmos w=1u l=1u m=1
XT419 vdd well_419 ntap1 A=4e-12 P=8e-6
XM69_7 net3 net70 vdd well_419 sg13_lv_pmos w=1u l=1u m=1
XT420 vdd well_420 ntap1 A=4e-12 P=8e-6
XM69_8 net3 net70 vdd well_420 sg13_lv_pmos w=1u l=1u m=1
XT421 vdd well_421 ntap1 A=4e-12 P=8e-6
XM69_9 net3 net70 vdd well_421 sg13_lv_pmos w=1u l=1u m=1
XT422 vdd well_422 ntap1 A=4e-12 P=8e-6
XM69_10 net3 net70 vdd well_422 sg13_lv_pmos w=1u l=1u m=1
XT423 vdd well_423 ntap1 A=4e-12 P=8e-6
XM69_11 net3 net70 vdd well_423 sg13_lv_pmos w=1u l=1u m=1
XT424 vdd well_424 ntap1 A=4e-12 P=8e-6
XM69_12 net3 net70 vdd well_424 sg13_lv_pmos w=1u l=1u m=1
XT425 vdd well_425 ntap1 A=4e-12 P=8e-6
XM69_13 net3 net70 vdd well_425 sg13_lv_pmos w=1u l=1u m=1
XT426 vdd well_426 ntap1 A=4e-12 P=8e-6
XM69_14 net3 net70 vdd well_426 sg13_lv_pmos w=1u l=1u m=1
XT427 vdd well_427 ntap1 A=4e-12 P=8e-6
XM69_15 net3 net70 vdd well_427 sg13_lv_pmos w=1u l=1u m=1
XT428 vdd well_428 ntap1 A=4e-12 P=8e-6
XM7_0 net049 voutn vdd well_428 sg13_lv_pmos w=1u l=1u m=1
XT429 vdd well_429 ntap1 A=4e-12 P=8e-6
XM7_1 net049 voutn vdd well_429 sg13_lv_pmos w=1u l=1u m=1
XT430 vdd well_430 ntap1 A=4e-12 P=8e-6
XM7_2 net049 voutn vdd well_430 sg13_lv_pmos w=1u l=1u m=1
XT431 vdd well_431 ntap1 A=4e-12 P=8e-6
XM7_3 net049 voutn vdd well_431 sg13_lv_pmos w=1u l=1u m=1
XT432 vss sub ptap1 A=4e-12 P=8e-6
XM70_0 net70 vb3 net69 sub sg13_lv_nmos w=1u l=1u m=1
XT433 vss sub ptap1 A=4e-12 P=8e-6
XM70_1 net70 vb3 net69 sub sg13_lv_nmos w=1u l=1u m=1
XT434 vss sub ptap1 A=4e-12 P=8e-6
XM70_2 net70 vb3 net69 sub sg13_lv_nmos w=1u l=1u m=1
XT435 vss sub ptap1 A=4e-12 P=8e-6
XM70_3 net70 vb3 net69 sub sg13_lv_nmos w=1u l=1u m=1
XT436 vss sub ptap1 A=4e-12 P=8e-6
XM70_4 net70 vb3 net69 sub sg13_lv_nmos w=1u l=1u m=1
XT437 vss sub ptap1 A=4e-12 P=8e-6
XM70_5 net70 vb3 net69 sub sg13_lv_nmos w=1u l=1u m=1
XT438 vss sub ptap1 A=4e-12 P=8e-6
XM70_6 net70 vb3 net69 sub sg13_lv_nmos w=1u l=1u m=1
XT439 vss sub ptap1 A=4e-12 P=8e-6
XM70_7 net70 vb3 net69 sub sg13_lv_nmos w=1u l=1u m=1
XT440 vss sub ptap1 A=4e-12 P=8e-6
XM70_8 net70 vb3 net69 sub sg13_lv_nmos w=1u l=1u m=1
XT441 vss sub ptap1 A=4e-12 P=8e-6
XM70_9 net70 vb3 net69 sub sg13_lv_nmos w=1u l=1u m=1
XT442 vss sub ptap1 A=4e-12 P=8e-6
XM70_10 net70 vb3 net69 sub sg13_lv_nmos w=1u l=1u m=1
XT443 vss sub ptap1 A=4e-12 P=8e-6
XM70_11 net70 vb3 net69 sub sg13_lv_nmos w=1u l=1u m=1
XT444 vss sub ptap1 A=4e-12 P=8e-6
XM70_12 net70 vb3 net69 sub sg13_lv_nmos w=1u l=1u m=1
XT445 vss sub ptap1 A=4e-12 P=8e-6
XM70_13 net70 vb3 net69 sub sg13_lv_nmos w=1u l=1u m=1
XT446 vss sub ptap1 A=4e-12 P=8e-6
XM70_14 net70 vb3 net69 sub sg13_lv_nmos w=1u l=1u m=1
XT447 vss sub ptap1 A=4e-12 P=8e-6
XM70_15 net70 vb3 net69 sub sg13_lv_nmos w=1u l=1u m=1
XT448 vss sub ptap1 A=4e-12 P=8e-6
XM71_0 voutn vb3 net85 sub sg13_lv_nmos w=1u l=1u m=1
XT449 vss sub ptap1 A=4e-12 P=8e-6
XM71_1 voutn vb3 net85 sub sg13_lv_nmos w=1u l=1u m=1
XT450 vss sub ptap1 A=4e-12 P=8e-6
XM71_2 voutn vb3 net85 sub sg13_lv_nmos w=1u l=1u m=1
XT451 vss sub ptap1 A=4e-12 P=8e-6
XM71_3 voutn vb3 net85 sub sg13_lv_nmos w=1u l=1u m=1
XT452 vss sub ptap1 A=4e-12 P=8e-6
XM71_4 voutn vb3 net85 sub sg13_lv_nmos w=1u l=1u m=1
XT453 vss sub ptap1 A=4e-12 P=8e-6
XM71_5 voutn vb3 net85 sub sg13_lv_nmos w=1u l=1u m=1
XT454 vss sub ptap1 A=4e-12 P=8e-6
XM71_6 voutn vb3 net85 sub sg13_lv_nmos w=1u l=1u m=1
XT455 vss sub ptap1 A=4e-12 P=8e-6
XM71_7 voutn vb3 net85 sub sg13_lv_nmos w=1u l=1u m=1
XT456 vss sub ptap1 A=4e-12 P=8e-6
XM71_8 voutn vb3 net85 sub sg13_lv_nmos w=1u l=1u m=1
XT457 vss sub ptap1 A=4e-12 P=8e-6
XM71_9 voutn vb3 net85 sub sg13_lv_nmos w=1u l=1u m=1
XT458 vss sub ptap1 A=4e-12 P=8e-6
XM71_10 voutn vb3 net85 sub sg13_lv_nmos w=1u l=1u m=1
XT459 vss sub ptap1 A=4e-12 P=8e-6
XM71_11 voutn vb3 net85 sub sg13_lv_nmos w=1u l=1u m=1
XT460 vss sub ptap1 A=4e-12 P=8e-6
XM71_12 voutn vb3 net85 sub sg13_lv_nmos w=1u l=1u m=1
XT461 vss sub ptap1 A=4e-12 P=8e-6
XM71_13 voutn vb3 net85 sub sg13_lv_nmos w=1u l=1u m=1
XT462 vss sub ptap1 A=4e-12 P=8e-6
XM71_14 voutn vb3 net85 sub sg13_lv_nmos w=1u l=1u m=1
XT463 vss sub ptap1 A=4e-12 P=8e-6
XM71_15 voutn vb3 net85 sub sg13_lv_nmos w=1u l=1u m=1
XT464 net31 well_464 ntap1 A=4e-12 P=8e-6
XM8_0 dm_2 vinn net31 well_464 sg13_lv_pmos w=1u l=1u m=1
XT465 net31 well_465 ntap1 A=4e-12 P=8e-6
XM8_1 dm_2 vinn net31 well_465 sg13_lv_pmos w=1u l=1u m=1
XT466 net31 well_466 ntap1 A=4e-12 P=8e-6
XM8_2 dm_2 vinn net31 well_466 sg13_lv_pmos w=1u l=1u m=1
XT467 net31 well_467 ntap1 A=4e-12 P=8e-6
XM8_3 dm_2 vinn net31 well_467 sg13_lv_pmos w=1u l=1u m=1
XT468 net31 well_468 ntap1 A=4e-12 P=8e-6
XM9_0 net063 vinp net31 well_468 sg13_lv_pmos w=1u l=1u m=1
XT469 net31 well_469 ntap1 A=4e-12 P=8e-6
XM9_1 net063 vinp net31 well_469 sg13_lv_pmos w=1u l=1u m=1
XT470 net31 well_470 ntap1 A=4e-12 P=8e-6
XM9_2 net063 vinp net31 well_470 sg13_lv_pmos w=1u l=1u m=1
XT471 net31 well_471 ntap1 A=4e-12 P=8e-6
XM9_3 net063 vinp net31 well_471 sg13_lv_pmos w=1u l=1u m=1
XTSUB vss sub ptap1 A=4e-12 P=8e-6
XC0_0 vout net70 cap_cmim w=31.57u l=31.57u m=1
XC2_0 net4 vss cap_cmim w=21.55u l=21.55u m=1
.ends amp_016_song_dacfc
