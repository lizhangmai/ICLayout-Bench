* Copyright 2026 Danial Noori Zadeh. See collection LICENSE and NOTICE.
* Fixed IHP binding; external bias ports and native physical taps.
.subckt amp_016_song_dacfc vss vdd vinn vinp vout net013
RT0 vdd well_0 ntap1 A=4e-12 P=8e-6
MM0_0 net013 net013 vdd well_0 sg13_lv_pmos w=1u l=1u m=1
RT1 vdd well_1 ntap1 A=4e-12 P=8e-6
MM0_1 net013 net013 vdd well_1 sg13_lv_pmos w=1u l=1u m=1
RT2 vdd well_2 ntap1 A=4e-12 P=8e-6
MM0_2 net013 net013 vdd well_2 sg13_lv_pmos w=1u l=1u m=1
RT3 vdd well_3 ntap1 A=4e-12 P=8e-6
MM0_3 net013 net013 vdd well_3 sg13_lv_pmos w=1u l=1u m=1
RT4 vdd well_4 ntap1 A=4e-12 P=8e-6
MM0_4 net013 net013 vdd well_4 sg13_lv_pmos w=1u l=1u m=1
RT5 vdd well_5 ntap1 A=4e-12 P=8e-6
MM0_5 net013 net013 vdd well_5 sg13_lv_pmos w=1u l=1u m=1
RT6 vdd well_6 ntap1 A=4e-12 P=8e-6
MM0_6 net013 net013 vdd well_6 sg13_lv_pmos w=1u l=1u m=1
RT7 vdd well_7 ntap1 A=4e-12 P=8e-6
MM0_7 net013 net013 vdd well_7 sg13_lv_pmos w=1u l=1u m=1
RT8 vdd well_8 ntap1 A=4e-12 P=8e-6
MM0_8 net013 net013 vdd well_8 sg13_lv_pmos w=1u l=1u m=1
RT9 vdd well_9 ntap1 A=4e-12 P=8e-6
MM0_9 net013 net013 vdd well_9 sg13_lv_pmos w=1u l=1u m=1
RT10 vdd well_10 ntap1 A=4e-12 P=8e-6
MM0_10 net013 net013 vdd well_10 sg13_lv_pmos w=1u l=1u m=1
RT11 vdd well_11 ntap1 A=4e-12 P=8e-6
MM0_11 net013 net013 vdd well_11 sg13_lv_pmos w=1u l=1u m=1
RT12 vdd well_12 ntap1 A=4e-12 P=8e-6
MM0_12 net013 net013 vdd well_12 sg13_lv_pmos w=1u l=1u m=1
RT13 vdd well_13 ntap1 A=4e-12 P=8e-6
MM0_13 net013 net013 vdd well_13 sg13_lv_pmos w=1u l=1u m=1
RT14 vdd well_14 ntap1 A=4e-12 P=8e-6
MM0_14 net013 net013 vdd well_14 sg13_lv_pmos w=1u l=1u m=1
RT15 vdd well_15 ntap1 A=4e-12 P=8e-6
MM0_15 net013 net013 vdd well_15 sg13_lv_pmos w=1u l=1u m=1
RT16 vdd well_16 ntap1 A=4e-12 P=8e-6
MM1_0 vb4 net013 vdd well_16 sg13_lv_pmos w=1u l=1u m=1
RT17 vdd well_17 ntap1 A=4e-12 P=8e-6
MM1_1 vb4 net013 vdd well_17 sg13_lv_pmos w=1u l=1u m=1
RT18 vdd well_18 ntap1 A=4e-12 P=8e-6
MM1_2 vb4 net013 vdd well_18 sg13_lv_pmos w=1u l=1u m=1
RT19 vdd well_19 ntap1 A=4e-12 P=8e-6
MM1_3 vb4 net013 vdd well_19 sg13_lv_pmos w=1u l=1u m=1
RT20 vdd well_20 ntap1 A=4e-12 P=8e-6
MM1_4 vb4 net013 vdd well_20 sg13_lv_pmos w=1u l=1u m=1
RT21 vdd well_21 ntap1 A=4e-12 P=8e-6
MM1_5 vb4 net013 vdd well_21 sg13_lv_pmos w=1u l=1u m=1
RT22 vdd well_22 ntap1 A=4e-12 P=8e-6
MM1_6 vb4 net013 vdd well_22 sg13_lv_pmos w=1u l=1u m=1
RT23 vdd well_23 ntap1 A=4e-12 P=8e-6
MM1_7 vb4 net013 vdd well_23 sg13_lv_pmos w=1u l=1u m=1
RT24 vdd well_24 ntap1 A=4e-12 P=8e-6
MM1_8 vb4 net013 vdd well_24 sg13_lv_pmos w=1u l=1u m=1
RT25 vdd well_25 ntap1 A=4e-12 P=8e-6
MM1_9 vb4 net013 vdd well_25 sg13_lv_pmos w=1u l=1u m=1
RT26 vdd well_26 ntap1 A=4e-12 P=8e-6
MM1_10 vb4 net013 vdd well_26 sg13_lv_pmos w=1u l=1u m=1
RT27 vdd well_27 ntap1 A=4e-12 P=8e-6
MM1_11 vb4 net013 vdd well_27 sg13_lv_pmos w=1u l=1u m=1
RT28 vdd well_28 ntap1 A=4e-12 P=8e-6
MM1_12 vb4 net013 vdd well_28 sg13_lv_pmos w=1u l=1u m=1
RT29 vdd well_29 ntap1 A=4e-12 P=8e-6
MM1_13 vb4 net013 vdd well_29 sg13_lv_pmos w=1u l=1u m=1
RT30 vdd well_30 ntap1 A=4e-12 P=8e-6
MM1_14 vb4 net013 vdd well_30 sg13_lv_pmos w=1u l=1u m=1
RT31 vdd well_31 ntap1 A=4e-12 P=8e-6
MM1_15 vb4 net013 vdd well_31 sg13_lv_pmos w=1u l=1u m=1
RT32 vdd well_32 ntap1 A=4e-12 P=8e-6
MM10_0 net043 net4 vdd well_32 sg13_lv_pmos w=1u l=1u m=1
RT33 vdd well_33 ntap1 A=4e-12 P=8e-6
MM10_1 net043 net4 vdd well_33 sg13_lv_pmos w=1u l=1u m=1
RT34 vdd well_34 ntap1 A=4e-12 P=8e-6
MM10_2 net043 net4 vdd well_34 sg13_lv_pmos w=1u l=1u m=1
RT35 vdd well_35 ntap1 A=4e-12 P=8e-6
MM10_3 net043 net4 vdd well_35 sg13_lv_pmos w=1u l=1u m=1
RT36 vdd well_36 ntap1 A=4e-12 P=8e-6
MM11_0 vout net4 vdd well_36 sg13_lv_pmos w=1u l=1u m=1
RT37 vdd well_37 ntap1 A=4e-12 P=8e-6
MM11_1 vout net4 vdd well_37 sg13_lv_pmos w=1u l=1u m=1
RT38 vdd well_38 ntap1 A=4e-12 P=8e-6
MM11_2 vout net4 vdd well_38 sg13_lv_pmos w=1u l=1u m=1
RT39 vdd well_39 ntap1 A=4e-12 P=8e-6
MM11_3 vout net4 vdd well_39 sg13_lv_pmos w=1u l=1u m=1
RT40 vss sub ptap1 A=4e-12 P=8e-6
MM12_0 vb4 vb3 net54 sub sg13_lv_nmos w=1u l=1u m=1
RT41 vss sub ptap1 A=4e-12 P=8e-6
MM12_1 vb4 vb3 net54 sub sg13_lv_nmos w=1u l=1u m=1
RT42 vss sub ptap1 A=4e-12 P=8e-6
MM12_2 vb4 vb3 net54 sub sg13_lv_nmos w=1u l=1u m=1
RT43 vss sub ptap1 A=4e-12 P=8e-6
MM12_3 vb4 vb3 net54 sub sg13_lv_nmos w=1u l=1u m=1
RT44 vss sub ptap1 A=4e-12 P=8e-6
MM12_4 vb4 vb3 net54 sub sg13_lv_nmos w=1u l=1u m=1
RT45 vss sub ptap1 A=4e-12 P=8e-6
MM12_5 vb4 vb3 net54 sub sg13_lv_nmos w=1u l=1u m=1
RT46 vss sub ptap1 A=4e-12 P=8e-6
MM12_6 vb4 vb3 net54 sub sg13_lv_nmos w=1u l=1u m=1
RT47 vss sub ptap1 A=4e-12 P=8e-6
MM12_7 vb4 vb3 net54 sub sg13_lv_nmos w=1u l=1u m=1
RT48 vss sub ptap1 A=4e-12 P=8e-6
MM12_8 vb4 vb3 net54 sub sg13_lv_nmos w=1u l=1u m=1
RT49 vss sub ptap1 A=4e-12 P=8e-6
MM12_9 vb4 vb3 net54 sub sg13_lv_nmos w=1u l=1u m=1
RT50 vss sub ptap1 A=4e-12 P=8e-6
MM12_10 vb4 vb3 net54 sub sg13_lv_nmos w=1u l=1u m=1
RT51 vss sub ptap1 A=4e-12 P=8e-6
MM12_11 vb4 vb3 net54 sub sg13_lv_nmos w=1u l=1u m=1
RT52 vss sub ptap1 A=4e-12 P=8e-6
MM12_12 vb4 vb3 net54 sub sg13_lv_nmos w=1u l=1u m=1
RT53 vss sub ptap1 A=4e-12 P=8e-6
MM12_13 vb4 vb3 net54 sub sg13_lv_nmos w=1u l=1u m=1
RT54 vss sub ptap1 A=4e-12 P=8e-6
MM12_14 vb4 vb3 net54 sub sg13_lv_nmos w=1u l=1u m=1
RT55 vss sub ptap1 A=4e-12 P=8e-6
MM12_15 vb4 vb3 net54 sub sg13_lv_nmos w=1u l=1u m=1
RT56 vss sub ptap1 A=4e-12 P=8e-6
MM13_0 dm_1 vb3 net56 sub sg13_lv_nmos w=1u l=1u m=1
RT57 vss sub ptap1 A=4e-12 P=8e-6
MM13_1 dm_1 vb3 net56 sub sg13_lv_nmos w=1u l=1u m=1
RT58 vss sub ptap1 A=4e-12 P=8e-6
MM13_2 dm_1 vb3 net56 sub sg13_lv_nmos w=1u l=1u m=1
RT59 vss sub ptap1 A=4e-12 P=8e-6
MM13_3 dm_1 vb3 net56 sub sg13_lv_nmos w=1u l=1u m=1
RT60 vss sub ptap1 A=4e-12 P=8e-6
MM13_4 dm_1 vb3 net56 sub sg13_lv_nmos w=1u l=1u m=1
RT61 vss sub ptap1 A=4e-12 P=8e-6
MM13_5 dm_1 vb3 net56 sub sg13_lv_nmos w=1u l=1u m=1
RT62 vss sub ptap1 A=4e-12 P=8e-6
MM13_6 dm_1 vb3 net56 sub sg13_lv_nmos w=1u l=1u m=1
RT63 vss sub ptap1 A=4e-12 P=8e-6
MM13_7 dm_1 vb3 net56 sub sg13_lv_nmos w=1u l=1u m=1
RT64 vss sub ptap1 A=4e-12 P=8e-6
MM13_8 dm_1 vb3 net56 sub sg13_lv_nmos w=1u l=1u m=1
RT65 vss sub ptap1 A=4e-12 P=8e-6
MM13_9 dm_1 vb3 net56 sub sg13_lv_nmos w=1u l=1u m=1
RT66 vss sub ptap1 A=4e-12 P=8e-6
MM13_10 dm_1 vb3 net56 sub sg13_lv_nmos w=1u l=1u m=1
RT67 vss sub ptap1 A=4e-12 P=8e-6
MM13_11 dm_1 vb3 net56 sub sg13_lv_nmos w=1u l=1u m=1
RT68 vss sub ptap1 A=4e-12 P=8e-6
MM13_12 dm_1 vb3 net56 sub sg13_lv_nmos w=1u l=1u m=1
RT69 vss sub ptap1 A=4e-12 P=8e-6
MM13_13 dm_1 vb3 net56 sub sg13_lv_nmos w=1u l=1u m=1
RT70 vss sub ptap1 A=4e-12 P=8e-6
MM13_14 dm_1 vb3 net56 sub sg13_lv_nmos w=1u l=1u m=1
RT71 vss sub ptap1 A=4e-12 P=8e-6
MM13_15 dm_1 vb3 net56 sub sg13_lv_nmos w=1u l=1u m=1
RT72 vss sub ptap1 A=4e-12 P=8e-6
MM14_0 vb3 vb3 vss sub sg13_lv_nmos w=1u l=1u m=1
RT73 vss sub ptap1 A=4e-12 P=8e-6
MM14_1 vb3 vb3 vss sub sg13_lv_nmos w=1u l=1u m=1
RT74 vss sub ptap1 A=4e-12 P=8e-6
MM14_2 vb3 vb3 vss sub sg13_lv_nmos w=1u l=1u m=1
RT75 vss sub ptap1 A=4e-12 P=8e-6
MM14_3 vb3 vb3 vss sub sg13_lv_nmos w=1u l=1u m=1
RT76 vss sub ptap1 A=4e-12 P=8e-6
MM15_0 voutn vb3 dm_2 sub sg13_lv_nmos w=1u l=1u m=1
RT77 vss sub ptap1 A=4e-12 P=8e-6
MM15_1 voutn vb3 dm_2 sub sg13_lv_nmos w=1u l=1u m=1
RT78 vss sub ptap1 A=4e-12 P=8e-6
MM15_2 voutn vb3 dm_2 sub sg13_lv_nmos w=1u l=1u m=1
RT79 vss sub ptap1 A=4e-12 P=8e-6
MM15_3 voutn vb3 dm_2 sub sg13_lv_nmos w=1u l=1u m=1
RT80 vss sub ptap1 A=4e-12 P=8e-6
MM15_4 voutn vb3 dm_2 sub sg13_lv_nmos w=1u l=1u m=1
RT81 vss sub ptap1 A=4e-12 P=8e-6
MM15_5 voutn vb3 dm_2 sub sg13_lv_nmos w=1u l=1u m=1
RT82 vss sub ptap1 A=4e-12 P=8e-6
MM15_6 voutn vb3 dm_2 sub sg13_lv_nmos w=1u l=1u m=1
RT83 vss sub ptap1 A=4e-12 P=8e-6
MM15_7 voutn vb3 dm_2 sub sg13_lv_nmos w=1u l=1u m=1
RT84 vss sub ptap1 A=4e-12 P=8e-6
MM15_8 voutn vb3 dm_2 sub sg13_lv_nmos w=1u l=1u m=1
RT85 vss sub ptap1 A=4e-12 P=8e-6
MM15_9 voutn vb3 dm_2 sub sg13_lv_nmos w=1u l=1u m=1
RT86 vss sub ptap1 A=4e-12 P=8e-6
MM15_10 voutn vb3 dm_2 sub sg13_lv_nmos w=1u l=1u m=1
RT87 vss sub ptap1 A=4e-12 P=8e-6
MM15_11 voutn vb3 dm_2 sub sg13_lv_nmos w=1u l=1u m=1
RT88 vss sub ptap1 A=4e-12 P=8e-6
MM15_12 voutn vb3 dm_2 sub sg13_lv_nmos w=1u l=1u m=1
RT89 vss sub ptap1 A=4e-12 P=8e-6
MM15_13 voutn vb3 dm_2 sub sg13_lv_nmos w=1u l=1u m=1
RT90 vss sub ptap1 A=4e-12 P=8e-6
MM15_14 voutn vb3 dm_2 sub sg13_lv_nmos w=1u l=1u m=1
RT91 vss sub ptap1 A=4e-12 P=8e-6
MM15_15 voutn vb3 dm_2 sub sg13_lv_nmos w=1u l=1u m=1
RT92 vss sub ptap1 A=4e-12 P=8e-6
MM16_0 net4 vb3 net063 sub sg13_lv_nmos w=1u l=1u m=1
RT93 vss sub ptap1 A=4e-12 P=8e-6
MM16_1 net4 vb3 net063 sub sg13_lv_nmos w=1u l=1u m=1
RT94 vss sub ptap1 A=4e-12 P=8e-6
MM16_2 net4 vb3 net063 sub sg13_lv_nmos w=1u l=1u m=1
RT95 vss sub ptap1 A=4e-12 P=8e-6
MM16_3 net4 vb3 net063 sub sg13_lv_nmos w=1u l=1u m=1
RT96 vss sub ptap1 A=4e-12 P=8e-6
MM16_4 net4 vb3 net063 sub sg13_lv_nmos w=1u l=1u m=1
RT97 vss sub ptap1 A=4e-12 P=8e-6
MM16_5 net4 vb3 net063 sub sg13_lv_nmos w=1u l=1u m=1
RT98 vss sub ptap1 A=4e-12 P=8e-6
MM16_6 net4 vb3 net063 sub sg13_lv_nmos w=1u l=1u m=1
RT99 vss sub ptap1 A=4e-12 P=8e-6
MM16_7 net4 vb3 net063 sub sg13_lv_nmos w=1u l=1u m=1
RT100 vss sub ptap1 A=4e-12 P=8e-6
MM16_8 net4 vb3 net063 sub sg13_lv_nmos w=1u l=1u m=1
RT101 vss sub ptap1 A=4e-12 P=8e-6
MM16_9 net4 vb3 net063 sub sg13_lv_nmos w=1u l=1u m=1
RT102 vss sub ptap1 A=4e-12 P=8e-6
MM16_10 net4 vb3 net063 sub sg13_lv_nmos w=1u l=1u m=1
RT103 vss sub ptap1 A=4e-12 P=8e-6
MM16_11 net4 vb3 net063 sub sg13_lv_nmos w=1u l=1u m=1
RT104 vss sub ptap1 A=4e-12 P=8e-6
MM16_12 net4 vb3 net063 sub sg13_lv_nmos w=1u l=1u m=1
RT105 vss sub ptap1 A=4e-12 P=8e-6
MM16_13 net4 vb3 net063 sub sg13_lv_nmos w=1u l=1u m=1
RT106 vss sub ptap1 A=4e-12 P=8e-6
MM16_14 net4 vb3 net063 sub sg13_lv_nmos w=1u l=1u m=1
RT107 vss sub ptap1 A=4e-12 P=8e-6
MM16_15 net4 vb3 net063 sub sg13_lv_nmos w=1u l=1u m=1
RT108 vss sub ptap1 A=4e-12 P=8e-6
MM17_0 net54 vb4 vss sub sg13_lv_nmos w=1u l=1u m=1
RT109 vss sub ptap1 A=4e-12 P=8e-6
MM17_1 net54 vb4 vss sub sg13_lv_nmos w=1u l=1u m=1
RT110 vss sub ptap1 A=4e-12 P=8e-6
MM17_2 net54 vb4 vss sub sg13_lv_nmos w=1u l=1u m=1
RT111 vss sub ptap1 A=4e-12 P=8e-6
MM17_3 net54 vb4 vss sub sg13_lv_nmos w=1u l=1u m=1
RT112 vss sub ptap1 A=4e-12 P=8e-6
MM17_4 net54 vb4 vss sub sg13_lv_nmos w=1u l=1u m=1
RT113 vss sub ptap1 A=4e-12 P=8e-6
MM17_5 net54 vb4 vss sub sg13_lv_nmos w=1u l=1u m=1
RT114 vss sub ptap1 A=4e-12 P=8e-6
MM17_6 net54 vb4 vss sub sg13_lv_nmos w=1u l=1u m=1
RT115 vss sub ptap1 A=4e-12 P=8e-6
MM17_7 net54 vb4 vss sub sg13_lv_nmos w=1u l=1u m=1
RT116 vss sub ptap1 A=4e-12 P=8e-6
MM17_8 net54 vb4 vss sub sg13_lv_nmos w=1u l=1u m=1
RT117 vss sub ptap1 A=4e-12 P=8e-6
MM17_9 net54 vb4 vss sub sg13_lv_nmos w=1u l=1u m=1
RT118 vss sub ptap1 A=4e-12 P=8e-6
MM17_10 net54 vb4 vss sub sg13_lv_nmos w=1u l=1u m=1
RT119 vss sub ptap1 A=4e-12 P=8e-6
MM17_11 net54 vb4 vss sub sg13_lv_nmos w=1u l=1u m=1
RT120 vss sub ptap1 A=4e-12 P=8e-6
MM17_12 net54 vb4 vss sub sg13_lv_nmos w=1u l=1u m=1
RT121 vss sub ptap1 A=4e-12 P=8e-6
MM17_13 net54 vb4 vss sub sg13_lv_nmos w=1u l=1u m=1
RT122 vss sub ptap1 A=4e-12 P=8e-6
MM17_14 net54 vb4 vss sub sg13_lv_nmos w=1u l=1u m=1
RT123 vss sub ptap1 A=4e-12 P=8e-6
MM17_15 net54 vb4 vss sub sg13_lv_nmos w=1u l=1u m=1
RT124 vss sub ptap1 A=4e-12 P=8e-6
MM18_0 net56 vb4 vss sub sg13_lv_nmos w=1u l=1u m=1
RT125 vss sub ptap1 A=4e-12 P=8e-6
MM18_1 net56 vb4 vss sub sg13_lv_nmos w=1u l=1u m=1
RT126 vss sub ptap1 A=4e-12 P=8e-6
MM18_2 net56 vb4 vss sub sg13_lv_nmos w=1u l=1u m=1
RT127 vss sub ptap1 A=4e-12 P=8e-6
MM18_3 net56 vb4 vss sub sg13_lv_nmos w=1u l=1u m=1
RT128 vss sub ptap1 A=4e-12 P=8e-6
MM18_4 net56 vb4 vss sub sg13_lv_nmos w=1u l=1u m=1
RT129 vss sub ptap1 A=4e-12 P=8e-6
MM18_5 net56 vb4 vss sub sg13_lv_nmos w=1u l=1u m=1
RT130 vss sub ptap1 A=4e-12 P=8e-6
MM18_6 net56 vb4 vss sub sg13_lv_nmos w=1u l=1u m=1
RT131 vss sub ptap1 A=4e-12 P=8e-6
MM18_7 net56 vb4 vss sub sg13_lv_nmos w=1u l=1u m=1
RT132 vss sub ptap1 A=4e-12 P=8e-6
MM18_8 net56 vb4 vss sub sg13_lv_nmos w=1u l=1u m=1
RT133 vss sub ptap1 A=4e-12 P=8e-6
MM18_9 net56 vb4 vss sub sg13_lv_nmos w=1u l=1u m=1
RT134 vss sub ptap1 A=4e-12 P=8e-6
MM18_10 net56 vb4 vss sub sg13_lv_nmos w=1u l=1u m=1
RT135 vss sub ptap1 A=4e-12 P=8e-6
MM18_11 net56 vb4 vss sub sg13_lv_nmos w=1u l=1u m=1
RT136 vss sub ptap1 A=4e-12 P=8e-6
MM18_12 net56 vb4 vss sub sg13_lv_nmos w=1u l=1u m=1
RT137 vss sub ptap1 A=4e-12 P=8e-6
MM18_13 net56 vb4 vss sub sg13_lv_nmos w=1u l=1u m=1
RT138 vss sub ptap1 A=4e-12 P=8e-6
MM18_14 net56 vb4 vss sub sg13_lv_nmos w=1u l=1u m=1
RT139 vss sub ptap1 A=4e-12 P=8e-6
MM18_15 net56 vb4 vss sub sg13_lv_nmos w=1u l=1u m=1
RT140 vss sub ptap1 A=4e-12 P=8e-6
MM19_0 dm_2 vb4 vss sub sg13_lv_nmos w=1u l=1u m=1
RT141 vss sub ptap1 A=4e-12 P=8e-6
MM19_1 dm_2 vb4 vss sub sg13_lv_nmos w=1u l=1u m=1
RT142 vss sub ptap1 A=4e-12 P=8e-6
MM19_2 dm_2 vb4 vss sub sg13_lv_nmos w=1u l=1u m=1
RT143 vss sub ptap1 A=4e-12 P=8e-6
MM19_3 dm_2 vb4 vss sub sg13_lv_nmos w=1u l=1u m=1
RT144 vss sub ptap1 A=4e-12 P=8e-6
MM19_4 dm_2 vb4 vss sub sg13_lv_nmos w=1u l=1u m=1
RT145 vss sub ptap1 A=4e-12 P=8e-6
MM19_5 dm_2 vb4 vss sub sg13_lv_nmos w=1u l=1u m=1
RT146 vss sub ptap1 A=4e-12 P=8e-6
MM19_6 dm_2 vb4 vss sub sg13_lv_nmos w=1u l=1u m=1
RT147 vss sub ptap1 A=4e-12 P=8e-6
MM19_7 dm_2 vb4 vss sub sg13_lv_nmos w=1u l=1u m=1
RT148 vss sub ptap1 A=4e-12 P=8e-6
MM19_8 dm_2 vb4 vss sub sg13_lv_nmos w=1u l=1u m=1
RT149 vss sub ptap1 A=4e-12 P=8e-6
MM19_9 dm_2 vb4 vss sub sg13_lv_nmos w=1u l=1u m=1
RT150 vss sub ptap1 A=4e-12 P=8e-6
MM19_10 dm_2 vb4 vss sub sg13_lv_nmos w=1u l=1u m=1
RT151 vss sub ptap1 A=4e-12 P=8e-6
MM19_11 dm_2 vb4 vss sub sg13_lv_nmos w=1u l=1u m=1
RT152 vss sub ptap1 A=4e-12 P=8e-6
MM19_12 dm_2 vb4 vss sub sg13_lv_nmos w=1u l=1u m=1
RT153 vss sub ptap1 A=4e-12 P=8e-6
MM19_13 dm_2 vb4 vss sub sg13_lv_nmos w=1u l=1u m=1
RT154 vss sub ptap1 A=4e-12 P=8e-6
MM19_14 dm_2 vb4 vss sub sg13_lv_nmos w=1u l=1u m=1
RT155 vss sub ptap1 A=4e-12 P=8e-6
MM19_15 dm_2 vb4 vss sub sg13_lv_nmos w=1u l=1u m=1
RT156 vss sub ptap1 A=4e-12 P=8e-6
MM19_16 dm_2 vb4 vss sub sg13_lv_nmos w=1u l=1u m=1
RT157 vss sub ptap1 A=4e-12 P=8e-6
MM19_17 dm_2 vb4 vss sub sg13_lv_nmos w=1u l=1u m=1
RT158 vss sub ptap1 A=4e-12 P=8e-6
MM19_18 dm_2 vb4 vss sub sg13_lv_nmos w=1u l=1u m=1
RT159 vss sub ptap1 A=4e-12 P=8e-6
MM19_19 dm_2 vb4 vss sub sg13_lv_nmos w=1u l=1u m=1
RT160 vss sub ptap1 A=4e-12 P=8e-6
MM19_20 dm_2 vb4 vss sub sg13_lv_nmos w=1u l=1u m=1
RT161 vss sub ptap1 A=4e-12 P=8e-6
MM19_21 dm_2 vb4 vss sub sg13_lv_nmos w=1u l=1u m=1
RT162 vss sub ptap1 A=4e-12 P=8e-6
MM19_22 dm_2 vb4 vss sub sg13_lv_nmos w=1u l=1u m=1
RT163 vss sub ptap1 A=4e-12 P=8e-6
MM19_23 dm_2 vb4 vss sub sg13_lv_nmos w=1u l=1u m=1
RT164 vss sub ptap1 A=4e-12 P=8e-6
MM19_24 dm_2 vb4 vss sub sg13_lv_nmos w=1u l=1u m=1
RT165 vss sub ptap1 A=4e-12 P=8e-6
MM19_25 dm_2 vb4 vss sub sg13_lv_nmos w=1u l=1u m=1
RT166 vss sub ptap1 A=4e-12 P=8e-6
MM19_26 dm_2 vb4 vss sub sg13_lv_nmos w=1u l=1u m=1
RT167 vss sub ptap1 A=4e-12 P=8e-6
MM19_27 dm_2 vb4 vss sub sg13_lv_nmos w=1u l=1u m=1
RT168 vss sub ptap1 A=4e-12 P=8e-6
MM19_28 dm_2 vb4 vss sub sg13_lv_nmos w=1u l=1u m=1
RT169 vss sub ptap1 A=4e-12 P=8e-6
MM19_29 dm_2 vb4 vss sub sg13_lv_nmos w=1u l=1u m=1
RT170 vss sub ptap1 A=4e-12 P=8e-6
MM19_30 dm_2 vb4 vss sub sg13_lv_nmos w=1u l=1u m=1
RT171 vss sub ptap1 A=4e-12 P=8e-6
MM19_31 dm_2 vb4 vss sub sg13_lv_nmos w=1u l=1u m=1
RT172 vdd well_172 ntap1 A=4e-12 P=8e-6
MM2_0 dm_1 dm_1 vdd well_172 sg13_lv_pmos w=1u l=1u m=1
RT173 vdd well_173 ntap1 A=4e-12 P=8e-6
MM2_1 dm_1 dm_1 vdd well_173 sg13_lv_pmos w=1u l=1u m=1
RT174 vdd well_174 ntap1 A=4e-12 P=8e-6
MM2_2 dm_1 dm_1 vdd well_174 sg13_lv_pmos w=1u l=1u m=1
RT175 vdd well_175 ntap1 A=4e-12 P=8e-6
MM2_3 dm_1 dm_1 vdd well_175 sg13_lv_pmos w=1u l=1u m=1
RT176 vss sub ptap1 A=4e-12 P=8e-6
MM20_0 net063 vb4 vss sub sg13_lv_nmos w=1u l=1u m=1
RT177 vss sub ptap1 A=4e-12 P=8e-6
MM20_1 net063 vb4 vss sub sg13_lv_nmos w=1u l=1u m=1
RT178 vss sub ptap1 A=4e-12 P=8e-6
MM20_2 net063 vb4 vss sub sg13_lv_nmos w=1u l=1u m=1
RT179 vss sub ptap1 A=4e-12 P=8e-6
MM20_3 net063 vb4 vss sub sg13_lv_nmos w=1u l=1u m=1
RT180 vss sub ptap1 A=4e-12 P=8e-6
MM20_4 net063 vb4 vss sub sg13_lv_nmos w=1u l=1u m=1
RT181 vss sub ptap1 A=4e-12 P=8e-6
MM20_5 net063 vb4 vss sub sg13_lv_nmos w=1u l=1u m=1
RT182 vss sub ptap1 A=4e-12 P=8e-6
MM20_6 net063 vb4 vss sub sg13_lv_nmos w=1u l=1u m=1
RT183 vss sub ptap1 A=4e-12 P=8e-6
MM20_7 net063 vb4 vss sub sg13_lv_nmos w=1u l=1u m=1
RT184 vss sub ptap1 A=4e-12 P=8e-6
MM20_8 net063 vb4 vss sub sg13_lv_nmos w=1u l=1u m=1
RT185 vss sub ptap1 A=4e-12 P=8e-6
MM20_9 net063 vb4 vss sub sg13_lv_nmos w=1u l=1u m=1
RT186 vss sub ptap1 A=4e-12 P=8e-6
MM20_10 net063 vb4 vss sub sg13_lv_nmos w=1u l=1u m=1
RT187 vss sub ptap1 A=4e-12 P=8e-6
MM20_11 net063 vb4 vss sub sg13_lv_nmos w=1u l=1u m=1
RT188 vss sub ptap1 A=4e-12 P=8e-6
MM20_12 net063 vb4 vss sub sg13_lv_nmos w=1u l=1u m=1
RT189 vss sub ptap1 A=4e-12 P=8e-6
MM20_13 net063 vb4 vss sub sg13_lv_nmos w=1u l=1u m=1
RT190 vss sub ptap1 A=4e-12 P=8e-6
MM20_14 net063 vb4 vss sub sg13_lv_nmos w=1u l=1u m=1
RT191 vss sub ptap1 A=4e-12 P=8e-6
MM20_15 net063 vb4 vss sub sg13_lv_nmos w=1u l=1u m=1
RT192 vss sub ptap1 A=4e-12 P=8e-6
MM20_16 net063 vb4 vss sub sg13_lv_nmos w=1u l=1u m=1
RT193 vss sub ptap1 A=4e-12 P=8e-6
MM20_17 net063 vb4 vss sub sg13_lv_nmos w=1u l=1u m=1
RT194 vss sub ptap1 A=4e-12 P=8e-6
MM20_18 net063 vb4 vss sub sg13_lv_nmos w=1u l=1u m=1
RT195 vss sub ptap1 A=4e-12 P=8e-6
MM20_19 net063 vb4 vss sub sg13_lv_nmos w=1u l=1u m=1
RT196 vss sub ptap1 A=4e-12 P=8e-6
MM20_20 net063 vb4 vss sub sg13_lv_nmos w=1u l=1u m=1
RT197 vss sub ptap1 A=4e-12 P=8e-6
MM20_21 net063 vb4 vss sub sg13_lv_nmos w=1u l=1u m=1
RT198 vss sub ptap1 A=4e-12 P=8e-6
MM20_22 net063 vb4 vss sub sg13_lv_nmos w=1u l=1u m=1
RT199 vss sub ptap1 A=4e-12 P=8e-6
MM20_23 net063 vb4 vss sub sg13_lv_nmos w=1u l=1u m=1
RT200 vss sub ptap1 A=4e-12 P=8e-6
MM20_24 net063 vb4 vss sub sg13_lv_nmos w=1u l=1u m=1
RT201 vss sub ptap1 A=4e-12 P=8e-6
MM20_25 net063 vb4 vss sub sg13_lv_nmos w=1u l=1u m=1
RT202 vss sub ptap1 A=4e-12 P=8e-6
MM20_26 net063 vb4 vss sub sg13_lv_nmos w=1u l=1u m=1
RT203 vss sub ptap1 A=4e-12 P=8e-6
MM20_27 net063 vb4 vss sub sg13_lv_nmos w=1u l=1u m=1
RT204 vss sub ptap1 A=4e-12 P=8e-6
MM20_28 net063 vb4 vss sub sg13_lv_nmos w=1u l=1u m=1
RT205 vss sub ptap1 A=4e-12 P=8e-6
MM20_29 net063 vb4 vss sub sg13_lv_nmos w=1u l=1u m=1
RT206 vss sub ptap1 A=4e-12 P=8e-6
MM20_30 net063 vb4 vss sub sg13_lv_nmos w=1u l=1u m=1
RT207 vss sub ptap1 A=4e-12 P=8e-6
MM20_31 net063 vb4 vss sub sg13_lv_nmos w=1u l=1u m=1
RT208 vss sub ptap1 A=4e-12 P=8e-6
MM21_0 net043 net043 vss sub sg13_lv_nmos w=1u l=1u m=1
RT209 vss sub ptap1 A=4e-12 P=8e-6
MM21_1 net043 net043 vss sub sg13_lv_nmos w=1u l=1u m=1
RT210 vss sub ptap1 A=4e-12 P=8e-6
MM21_2 net043 net043 vss sub sg13_lv_nmos w=1u l=1u m=1
RT211 vss sub ptap1 A=4e-12 P=8e-6
MM21_3 net043 net043 vss sub sg13_lv_nmos w=1u l=1u m=1
RT212 vss sub ptap1 A=4e-12 P=8e-6
MM22_0 net049 net043 vss sub sg13_lv_nmos w=1u l=1u m=1
RT213 vss sub ptap1 A=4e-12 P=8e-6
MM22_1 net049 net043 vss sub sg13_lv_nmos w=1u l=1u m=1
RT214 vss sub ptap1 A=4e-12 P=8e-6
MM22_2 net049 net043 vss sub sg13_lv_nmos w=1u l=1u m=1
RT215 vss sub ptap1 A=4e-12 P=8e-6
MM22_3 net049 net043 vss sub sg13_lv_nmos w=1u l=1u m=1
RT216 vss sub ptap1 A=4e-12 P=8e-6
MM23_0 vout net049 vss sub sg13_lv_nmos w=1u l=1u m=1
RT217 vss sub ptap1 A=4e-12 P=8e-6
MM23_1 vout net049 vss sub sg13_lv_nmos w=1u l=1u m=1
RT218 vss sub ptap1 A=4e-12 P=8e-6
MM23_2 vout net049 vss sub sg13_lv_nmos w=1u l=1u m=1
RT219 vss sub ptap1 A=4e-12 P=8e-6
MM23_3 vout net049 vss sub sg13_lv_nmos w=1u l=1u m=1
RT220 vdd well_220 ntap1 A=4e-12 P=8e-6
MM3_0 vb3 net013 vdd well_220 sg13_lv_pmos w=1u l=1u m=1
RT221 vdd well_221 ntap1 A=4e-12 P=8e-6
MM3_1 vb3 net013 vdd well_221 sg13_lv_pmos w=1u l=1u m=1
RT222 vdd well_222 ntap1 A=4e-12 P=8e-6
MM3_2 vb3 net013 vdd well_222 sg13_lv_pmos w=1u l=1u m=1
RT223 vdd well_223 ntap1 A=4e-12 P=8e-6
MM3_3 vb3 net013 vdd well_223 sg13_lv_pmos w=1u l=1u m=1
RT224 vdd well_224 ntap1 A=4e-12 P=8e-6
MM3_4 vb3 net013 vdd well_224 sg13_lv_pmos w=1u l=1u m=1
RT225 vdd well_225 ntap1 A=4e-12 P=8e-6
MM3_5 vb3 net013 vdd well_225 sg13_lv_pmos w=1u l=1u m=1
RT226 vdd well_226 ntap1 A=4e-12 P=8e-6
MM3_6 vb3 net013 vdd well_226 sg13_lv_pmos w=1u l=1u m=1
RT227 vdd well_227 ntap1 A=4e-12 P=8e-6
MM3_7 vb3 net013 vdd well_227 sg13_lv_pmos w=1u l=1u m=1
RT228 vdd well_228 ntap1 A=4e-12 P=8e-6
MM3_8 vb3 net013 vdd well_228 sg13_lv_pmos w=1u l=1u m=1
RT229 vdd well_229 ntap1 A=4e-12 P=8e-6
MM3_9 vb3 net013 vdd well_229 sg13_lv_pmos w=1u l=1u m=1
RT230 vdd well_230 ntap1 A=4e-12 P=8e-6
MM3_10 vb3 net013 vdd well_230 sg13_lv_pmos w=1u l=1u m=1
RT231 vdd well_231 ntap1 A=4e-12 P=8e-6
MM3_11 vb3 net013 vdd well_231 sg13_lv_pmos w=1u l=1u m=1
RT232 vdd well_232 ntap1 A=4e-12 P=8e-6
MM3_12 vb3 net013 vdd well_232 sg13_lv_pmos w=1u l=1u m=1
RT233 vdd well_233 ntap1 A=4e-12 P=8e-6
MM3_13 vb3 net013 vdd well_233 sg13_lv_pmos w=1u l=1u m=1
RT234 vdd well_234 ntap1 A=4e-12 P=8e-6
MM3_14 vb3 net013 vdd well_234 sg13_lv_pmos w=1u l=1u m=1
RT235 vdd well_235 ntap1 A=4e-12 P=8e-6
MM3_15 vb3 net013 vdd well_235 sg13_lv_pmos w=1u l=1u m=1
RT236 vdd well_236 ntap1 A=4e-12 P=8e-6
MM4_0 net31 net013 vdd well_236 sg13_lv_pmos w=1u l=1u m=1
RT237 vdd well_237 ntap1 A=4e-12 P=8e-6
MM4_1 net31 net013 vdd well_237 sg13_lv_pmos w=1u l=1u m=1
RT238 vdd well_238 ntap1 A=4e-12 P=8e-6
MM4_2 net31 net013 vdd well_238 sg13_lv_pmos w=1u l=1u m=1
RT239 vdd well_239 ntap1 A=4e-12 P=8e-6
MM4_3 net31 net013 vdd well_239 sg13_lv_pmos w=1u l=1u m=1
RT240 vdd well_240 ntap1 A=4e-12 P=8e-6
MM4_4 net31 net013 vdd well_240 sg13_lv_pmos w=1u l=1u m=1
RT241 vdd well_241 ntap1 A=4e-12 P=8e-6
MM4_5 net31 net013 vdd well_241 sg13_lv_pmos w=1u l=1u m=1
RT242 vdd well_242 ntap1 A=4e-12 P=8e-6
MM4_6 net31 net013 vdd well_242 sg13_lv_pmos w=1u l=1u m=1
RT243 vdd well_243 ntap1 A=4e-12 P=8e-6
MM4_7 net31 net013 vdd well_243 sg13_lv_pmos w=1u l=1u m=1
RT244 vdd well_244 ntap1 A=4e-12 P=8e-6
MM5_0 net5 voutn vdd well_244 sg13_lv_pmos w=1u l=1u m=1
RT245 vdd well_245 ntap1 A=4e-12 P=8e-6
MM5_1 net5 voutn vdd well_245 sg13_lv_pmos w=1u l=1u m=1
RT246 vdd well_246 ntap1 A=4e-12 P=8e-6
MM5_2 net5 voutn vdd well_246 sg13_lv_pmos w=1u l=1u m=1
RT247 vdd well_247 ntap1 A=4e-12 P=8e-6
MM5_3 net5 voutn vdd well_247 sg13_lv_pmos w=1u l=1u m=1
RT248 net1 well_248 ntap1 A=4e-12 P=8e-6
MM57_0 net043 vinn net1 well_248 sg13_lv_pmos w=1u l=1u m=1
RT249 net1 well_249 ntap1 A=4e-12 P=8e-6
MM57_1 net043 vinn net1 well_249 sg13_lv_pmos w=1u l=1u m=1
RT250 net1 well_250 ntap1 A=4e-12 P=8e-6
MM57_2 net043 vinn net1 well_250 sg13_lv_pmos w=1u l=1u m=1
RT251 net1 well_251 ntap1 A=4e-12 P=8e-6
MM57_3 net043 vinn net1 well_251 sg13_lv_pmos w=1u l=1u m=1
RT252 net1 well_252 ntap1 A=4e-12 P=8e-6
MM58_0 net049 vinp net1 well_252 sg13_lv_pmos w=1u l=1u m=1
RT253 net1 well_253 ntap1 A=4e-12 P=8e-6
MM58_1 net049 vinp net1 well_253 sg13_lv_pmos w=1u l=1u m=1
RT254 net1 well_254 ntap1 A=4e-12 P=8e-6
MM58_2 net049 vinp net1 well_254 sg13_lv_pmos w=1u l=1u m=1
RT255 net1 well_255 ntap1 A=4e-12 P=8e-6
MM58_3 net049 vinp net1 well_255 sg13_lv_pmos w=1u l=1u m=1
RT256 vdd well_256 ntap1 A=4e-12 P=8e-6
MM59_0 net1 net013 vdd well_256 sg13_lv_pmos w=1u l=1u m=1
RT257 vdd well_257 ntap1 A=4e-12 P=8e-6
MM59_1 net1 net013 vdd well_257 sg13_lv_pmos w=1u l=1u m=1
RT258 vdd well_258 ntap1 A=4e-12 P=8e-6
MM59_2 net1 net013 vdd well_258 sg13_lv_pmos w=1u l=1u m=1
RT259 vdd well_259 ntap1 A=4e-12 P=8e-6
MM59_3 net1 net013 vdd well_259 sg13_lv_pmos w=1u l=1u m=1
RT260 vdd well_260 ntap1 A=4e-12 P=8e-6
MM59_4 net1 net013 vdd well_260 sg13_lv_pmos w=1u l=1u m=1
RT261 vdd well_261 ntap1 A=4e-12 P=8e-6
MM59_5 net1 net013 vdd well_261 sg13_lv_pmos w=1u l=1u m=1
RT262 vdd well_262 ntap1 A=4e-12 P=8e-6
MM59_6 net1 net013 vdd well_262 sg13_lv_pmos w=1u l=1u m=1
RT263 vdd well_263 ntap1 A=4e-12 P=8e-6
MM59_7 net1 net013 vdd well_263 sg13_lv_pmos w=1u l=1u m=1
RT264 vdd well_264 ntap1 A=4e-12 P=8e-6
MM6_0 net050 voutn vdd well_264 sg13_lv_pmos w=1u l=1u m=1
RT265 vdd well_265 ntap1 A=4e-12 P=8e-6
MM6_1 net050 voutn vdd well_265 sg13_lv_pmos w=1u l=1u m=1
RT266 vdd well_266 ntap1 A=4e-12 P=8e-6
MM6_2 net050 voutn vdd well_266 sg13_lv_pmos w=1u l=1u m=1
RT267 vdd well_267 ntap1 A=4e-12 P=8e-6
MM6_3 net050 voutn vdd well_267 sg13_lv_pmos w=1u l=1u m=1
RT268 vdd well_268 ntap1 A=4e-12 P=8e-6
MM60_0 voutn dm_1 net5 well_268 sg13_lv_pmos w=1u l=1u m=1
RT269 vdd well_269 ntap1 A=4e-12 P=8e-6
MM60_1 voutn dm_1 net5 well_269 sg13_lv_pmos w=1u l=1u m=1
RT270 vdd well_270 ntap1 A=4e-12 P=8e-6
MM60_2 voutn dm_1 net5 well_270 sg13_lv_pmos w=1u l=1u m=1
RT271 vdd well_271 ntap1 A=4e-12 P=8e-6
MM60_3 voutn dm_1 net5 well_271 sg13_lv_pmos w=1u l=1u m=1
RT272 vdd well_272 ntap1 A=4e-12 P=8e-6
MM60_4 voutn dm_1 net5 well_272 sg13_lv_pmos w=1u l=1u m=1
RT273 vdd well_273 ntap1 A=4e-12 P=8e-6
MM60_5 voutn dm_1 net5 well_273 sg13_lv_pmos w=1u l=1u m=1
RT274 vdd well_274 ntap1 A=4e-12 P=8e-6
MM60_6 voutn dm_1 net5 well_274 sg13_lv_pmos w=1u l=1u m=1
RT275 vdd well_275 ntap1 A=4e-12 P=8e-6
MM60_7 voutn dm_1 net5 well_275 sg13_lv_pmos w=1u l=1u m=1
RT276 vdd well_276 ntap1 A=4e-12 P=8e-6
MM60_8 voutn dm_1 net5 well_276 sg13_lv_pmos w=1u l=1u m=1
RT277 vdd well_277 ntap1 A=4e-12 P=8e-6
MM60_9 voutn dm_1 net5 well_277 sg13_lv_pmos w=1u l=1u m=1
RT278 vdd well_278 ntap1 A=4e-12 P=8e-6
MM60_10 voutn dm_1 net5 well_278 sg13_lv_pmos w=1u l=1u m=1
RT279 vdd well_279 ntap1 A=4e-12 P=8e-6
MM60_11 voutn dm_1 net5 well_279 sg13_lv_pmos w=1u l=1u m=1
RT280 vdd well_280 ntap1 A=4e-12 P=8e-6
MM60_12 voutn dm_1 net5 well_280 sg13_lv_pmos w=1u l=1u m=1
RT281 vdd well_281 ntap1 A=4e-12 P=8e-6
MM60_13 voutn dm_1 net5 well_281 sg13_lv_pmos w=1u l=1u m=1
RT282 vdd well_282 ntap1 A=4e-12 P=8e-6
MM60_14 voutn dm_1 net5 well_282 sg13_lv_pmos w=1u l=1u m=1
RT283 vdd well_283 ntap1 A=4e-12 P=8e-6
MM60_15 voutn dm_1 net5 well_283 sg13_lv_pmos w=1u l=1u m=1
RT284 vdd well_284 ntap1 A=4e-12 P=8e-6
MM61_0 net4 dm_1 net050 well_284 sg13_lv_pmos w=1u l=1u m=1
RT285 vdd well_285 ntap1 A=4e-12 P=8e-6
MM61_1 net4 dm_1 net050 well_285 sg13_lv_pmos w=1u l=1u m=1
RT286 vdd well_286 ntap1 A=4e-12 P=8e-6
MM61_2 net4 dm_1 net050 well_286 sg13_lv_pmos w=1u l=1u m=1
RT287 vdd well_287 ntap1 A=4e-12 P=8e-6
MM61_3 net4 dm_1 net050 well_287 sg13_lv_pmos w=1u l=1u m=1
RT288 vdd well_288 ntap1 A=4e-12 P=8e-6
MM61_4 net4 dm_1 net050 well_288 sg13_lv_pmos w=1u l=1u m=1
RT289 vdd well_289 ntap1 A=4e-12 P=8e-6
MM61_5 net4 dm_1 net050 well_289 sg13_lv_pmos w=1u l=1u m=1
RT290 vdd well_290 ntap1 A=4e-12 P=8e-6
MM61_6 net4 dm_1 net050 well_290 sg13_lv_pmos w=1u l=1u m=1
RT291 vdd well_291 ntap1 A=4e-12 P=8e-6
MM61_7 net4 dm_1 net050 well_291 sg13_lv_pmos w=1u l=1u m=1
RT292 vdd well_292 ntap1 A=4e-12 P=8e-6
MM61_8 net4 dm_1 net050 well_292 sg13_lv_pmos w=1u l=1u m=1
RT293 vdd well_293 ntap1 A=4e-12 P=8e-6
MM61_9 net4 dm_1 net050 well_293 sg13_lv_pmos w=1u l=1u m=1
RT294 vdd well_294 ntap1 A=4e-12 P=8e-6
MM61_10 net4 dm_1 net050 well_294 sg13_lv_pmos w=1u l=1u m=1
RT295 vdd well_295 ntap1 A=4e-12 P=8e-6
MM61_11 net4 dm_1 net050 well_295 sg13_lv_pmos w=1u l=1u m=1
RT296 vdd well_296 ntap1 A=4e-12 P=8e-6
MM61_12 net4 dm_1 net050 well_296 sg13_lv_pmos w=1u l=1u m=1
RT297 vdd well_297 ntap1 A=4e-12 P=8e-6
MM61_13 net4 dm_1 net050 well_297 sg13_lv_pmos w=1u l=1u m=1
RT298 vdd well_298 ntap1 A=4e-12 P=8e-6
MM61_14 net4 dm_1 net050 well_298 sg13_lv_pmos w=1u l=1u m=1
RT299 vdd well_299 ntap1 A=4e-12 P=8e-6
MM61_15 net4 dm_1 net050 well_299 sg13_lv_pmos w=1u l=1u m=1
RT300 vdd well_300 ntap1 A=4e-12 P=8e-6
MM62_0 voutn dm_1 net3 well_300 sg13_lv_pmos w=1u l=1u m=1
RT301 vdd well_301 ntap1 A=4e-12 P=8e-6
MM62_1 voutn dm_1 net3 well_301 sg13_lv_pmos w=1u l=1u m=1
RT302 vdd well_302 ntap1 A=4e-12 P=8e-6
MM62_2 voutn dm_1 net3 well_302 sg13_lv_pmos w=1u l=1u m=1
RT303 vdd well_303 ntap1 A=4e-12 P=8e-6
MM62_3 voutn dm_1 net3 well_303 sg13_lv_pmos w=1u l=1u m=1
RT304 vdd well_304 ntap1 A=4e-12 P=8e-6
MM62_4 voutn dm_1 net3 well_304 sg13_lv_pmos w=1u l=1u m=1
RT305 vdd well_305 ntap1 A=4e-12 P=8e-6
MM62_5 voutn dm_1 net3 well_305 sg13_lv_pmos w=1u l=1u m=1
RT306 vdd well_306 ntap1 A=4e-12 P=8e-6
MM62_6 voutn dm_1 net3 well_306 sg13_lv_pmos w=1u l=1u m=1
RT307 vdd well_307 ntap1 A=4e-12 P=8e-6
MM62_7 voutn dm_1 net3 well_307 sg13_lv_pmos w=1u l=1u m=1
RT308 vdd well_308 ntap1 A=4e-12 P=8e-6
MM62_8 voutn dm_1 net3 well_308 sg13_lv_pmos w=1u l=1u m=1
RT309 vdd well_309 ntap1 A=4e-12 P=8e-6
MM62_9 voutn dm_1 net3 well_309 sg13_lv_pmos w=1u l=1u m=1
RT310 vdd well_310 ntap1 A=4e-12 P=8e-6
MM62_10 voutn dm_1 net3 well_310 sg13_lv_pmos w=1u l=1u m=1
RT311 vdd well_311 ntap1 A=4e-12 P=8e-6
MM62_11 voutn dm_1 net3 well_311 sg13_lv_pmos w=1u l=1u m=1
RT312 vdd well_312 ntap1 A=4e-12 P=8e-6
MM62_12 voutn dm_1 net3 well_312 sg13_lv_pmos w=1u l=1u m=1
RT313 vdd well_313 ntap1 A=4e-12 P=8e-6
MM62_13 voutn dm_1 net3 well_313 sg13_lv_pmos w=1u l=1u m=1
RT314 vdd well_314 ntap1 A=4e-12 P=8e-6
MM62_14 voutn dm_1 net3 well_314 sg13_lv_pmos w=1u l=1u m=1
RT315 vdd well_315 ntap1 A=4e-12 P=8e-6
MM62_15 voutn dm_1 net3 well_315 sg13_lv_pmos w=1u l=1u m=1
RT316 vdd well_316 ntap1 A=4e-12 P=8e-6
MM63_0 net70 dm_1 net2 well_316 sg13_lv_pmos w=1u l=1u m=1
RT317 vdd well_317 ntap1 A=4e-12 P=8e-6
MM63_1 net70 dm_1 net2 well_317 sg13_lv_pmos w=1u l=1u m=1
RT318 vdd well_318 ntap1 A=4e-12 P=8e-6
MM63_2 net70 dm_1 net2 well_318 sg13_lv_pmos w=1u l=1u m=1
RT319 vdd well_319 ntap1 A=4e-12 P=8e-6
MM63_3 net70 dm_1 net2 well_319 sg13_lv_pmos w=1u l=1u m=1
RT320 vdd well_320 ntap1 A=4e-12 P=8e-6
MM63_4 net70 dm_1 net2 well_320 sg13_lv_pmos w=1u l=1u m=1
RT321 vdd well_321 ntap1 A=4e-12 P=8e-6
MM63_5 net70 dm_1 net2 well_321 sg13_lv_pmos w=1u l=1u m=1
RT322 vdd well_322 ntap1 A=4e-12 P=8e-6
MM63_6 net70 dm_1 net2 well_322 sg13_lv_pmos w=1u l=1u m=1
RT323 vdd well_323 ntap1 A=4e-12 P=8e-6
MM63_7 net70 dm_1 net2 well_323 sg13_lv_pmos w=1u l=1u m=1
RT324 vdd well_324 ntap1 A=4e-12 P=8e-6
MM63_8 net70 dm_1 net2 well_324 sg13_lv_pmos w=1u l=1u m=1
RT325 vdd well_325 ntap1 A=4e-12 P=8e-6
MM63_9 net70 dm_1 net2 well_325 sg13_lv_pmos w=1u l=1u m=1
RT326 vdd well_326 ntap1 A=4e-12 P=8e-6
MM63_10 net70 dm_1 net2 well_326 sg13_lv_pmos w=1u l=1u m=1
RT327 vdd well_327 ntap1 A=4e-12 P=8e-6
MM63_11 net70 dm_1 net2 well_327 sg13_lv_pmos w=1u l=1u m=1
RT328 vdd well_328 ntap1 A=4e-12 P=8e-6
MM63_12 net70 dm_1 net2 well_328 sg13_lv_pmos w=1u l=1u m=1
RT329 vdd well_329 ntap1 A=4e-12 P=8e-6
MM63_13 net70 dm_1 net2 well_329 sg13_lv_pmos w=1u l=1u m=1
RT330 vdd well_330 ntap1 A=4e-12 P=8e-6
MM63_14 net70 dm_1 net2 well_330 sg13_lv_pmos w=1u l=1u m=1
RT331 vdd well_331 ntap1 A=4e-12 P=8e-6
MM63_15 net70 dm_1 net2 well_331 sg13_lv_pmos w=1u l=1u m=1
RT332 vss sub ptap1 A=4e-12 P=8e-6
MM64_0 net85 vb4 vss sub sg13_lv_nmos w=1u l=1u m=1
RT333 vss sub ptap1 A=4e-12 P=8e-6
MM64_1 net85 vb4 vss sub sg13_lv_nmos w=1u l=1u m=1
RT334 vss sub ptap1 A=4e-12 P=8e-6
MM64_2 net85 vb4 vss sub sg13_lv_nmos w=1u l=1u m=1
RT335 vss sub ptap1 A=4e-12 P=8e-6
MM64_3 net85 vb4 vss sub sg13_lv_nmos w=1u l=1u m=1
RT336 vss sub ptap1 A=4e-12 P=8e-6
MM64_4 net85 vb4 vss sub sg13_lv_nmos w=1u l=1u m=1
RT337 vss sub ptap1 A=4e-12 P=8e-6
MM64_5 net85 vb4 vss sub sg13_lv_nmos w=1u l=1u m=1
RT338 vss sub ptap1 A=4e-12 P=8e-6
MM64_6 net85 vb4 vss sub sg13_lv_nmos w=1u l=1u m=1
RT339 vss sub ptap1 A=4e-12 P=8e-6
MM64_7 net85 vb4 vss sub sg13_lv_nmos w=1u l=1u m=1
RT340 vss sub ptap1 A=4e-12 P=8e-6
MM64_8 net85 vb4 vss sub sg13_lv_nmos w=1u l=1u m=1
RT341 vss sub ptap1 A=4e-12 P=8e-6
MM64_9 net85 vb4 vss sub sg13_lv_nmos w=1u l=1u m=1
RT342 vss sub ptap1 A=4e-12 P=8e-6
MM64_10 net85 vb4 vss sub sg13_lv_nmos w=1u l=1u m=1
RT343 vss sub ptap1 A=4e-12 P=8e-6
MM64_11 net85 vb4 vss sub sg13_lv_nmos w=1u l=1u m=1
RT344 vss sub ptap1 A=4e-12 P=8e-6
MM64_12 net85 vb4 vss sub sg13_lv_nmos w=1u l=1u m=1
RT345 vss sub ptap1 A=4e-12 P=8e-6
MM64_13 net85 vb4 vss sub sg13_lv_nmos w=1u l=1u m=1
RT346 vss sub ptap1 A=4e-12 P=8e-6
MM64_14 net85 vb4 vss sub sg13_lv_nmos w=1u l=1u m=1
RT347 vss sub ptap1 A=4e-12 P=8e-6
MM64_15 net85 vb4 vss sub sg13_lv_nmos w=1u l=1u m=1
RT348 vss sub ptap1 A=4e-12 P=8e-6
MM64_16 net85 vb4 vss sub sg13_lv_nmos w=1u l=1u m=1
RT349 vss sub ptap1 A=4e-12 P=8e-6
MM64_17 net85 vb4 vss sub sg13_lv_nmos w=1u l=1u m=1
RT350 vss sub ptap1 A=4e-12 P=8e-6
MM64_18 net85 vb4 vss sub sg13_lv_nmos w=1u l=1u m=1
RT351 vss sub ptap1 A=4e-12 P=8e-6
MM64_19 net85 vb4 vss sub sg13_lv_nmos w=1u l=1u m=1
RT352 vss sub ptap1 A=4e-12 P=8e-6
MM64_20 net85 vb4 vss sub sg13_lv_nmos w=1u l=1u m=1
RT353 vss sub ptap1 A=4e-12 P=8e-6
MM64_21 net85 vb4 vss sub sg13_lv_nmos w=1u l=1u m=1
RT354 vss sub ptap1 A=4e-12 P=8e-6
MM64_22 net85 vb4 vss sub sg13_lv_nmos w=1u l=1u m=1
RT355 vss sub ptap1 A=4e-12 P=8e-6
MM64_23 net85 vb4 vss sub sg13_lv_nmos w=1u l=1u m=1
RT356 vss sub ptap1 A=4e-12 P=8e-6
MM64_24 net85 vb4 vss sub sg13_lv_nmos w=1u l=1u m=1
RT357 vss sub ptap1 A=4e-12 P=8e-6
MM64_25 net85 vb4 vss sub sg13_lv_nmos w=1u l=1u m=1
RT358 vss sub ptap1 A=4e-12 P=8e-6
MM64_26 net85 vb4 vss sub sg13_lv_nmos w=1u l=1u m=1
RT359 vss sub ptap1 A=4e-12 P=8e-6
MM64_27 net85 vb4 vss sub sg13_lv_nmos w=1u l=1u m=1
RT360 vss sub ptap1 A=4e-12 P=8e-6
MM64_28 net85 vb4 vss sub sg13_lv_nmos w=1u l=1u m=1
RT361 vss sub ptap1 A=4e-12 P=8e-6
MM64_29 net85 vb4 vss sub sg13_lv_nmos w=1u l=1u m=1
RT362 vss sub ptap1 A=4e-12 P=8e-6
MM64_30 net85 vb4 vss sub sg13_lv_nmos w=1u l=1u m=1
RT363 vss sub ptap1 A=4e-12 P=8e-6
MM64_31 net85 vb4 vss sub sg13_lv_nmos w=1u l=1u m=1
RT364 vss sub ptap1 A=4e-12 P=8e-6
MM65_0 net69 vb4 vss sub sg13_lv_nmos w=1u l=1u m=1
RT365 vss sub ptap1 A=4e-12 P=8e-6
MM65_1 net69 vb4 vss sub sg13_lv_nmos w=1u l=1u m=1
RT366 vss sub ptap1 A=4e-12 P=8e-6
MM65_2 net69 vb4 vss sub sg13_lv_nmos w=1u l=1u m=1
RT367 vss sub ptap1 A=4e-12 P=8e-6
MM65_3 net69 vb4 vss sub sg13_lv_nmos w=1u l=1u m=1
RT368 vss sub ptap1 A=4e-12 P=8e-6
MM65_4 net69 vb4 vss sub sg13_lv_nmos w=1u l=1u m=1
RT369 vss sub ptap1 A=4e-12 P=8e-6
MM65_5 net69 vb4 vss sub sg13_lv_nmos w=1u l=1u m=1
RT370 vss sub ptap1 A=4e-12 P=8e-6
MM65_6 net69 vb4 vss sub sg13_lv_nmos w=1u l=1u m=1
RT371 vss sub ptap1 A=4e-12 P=8e-6
MM65_7 net69 vb4 vss sub sg13_lv_nmos w=1u l=1u m=1
RT372 vss sub ptap1 A=4e-12 P=8e-6
MM65_8 net69 vb4 vss sub sg13_lv_nmos w=1u l=1u m=1
RT373 vss sub ptap1 A=4e-12 P=8e-6
MM65_9 net69 vb4 vss sub sg13_lv_nmos w=1u l=1u m=1
RT374 vss sub ptap1 A=4e-12 P=8e-6
MM65_10 net69 vb4 vss sub sg13_lv_nmos w=1u l=1u m=1
RT375 vss sub ptap1 A=4e-12 P=8e-6
MM65_11 net69 vb4 vss sub sg13_lv_nmos w=1u l=1u m=1
RT376 vss sub ptap1 A=4e-12 P=8e-6
MM65_12 net69 vb4 vss sub sg13_lv_nmos w=1u l=1u m=1
RT377 vss sub ptap1 A=4e-12 P=8e-6
MM65_13 net69 vb4 vss sub sg13_lv_nmos w=1u l=1u m=1
RT378 vss sub ptap1 A=4e-12 P=8e-6
MM65_14 net69 vb4 vss sub sg13_lv_nmos w=1u l=1u m=1
RT379 vss sub ptap1 A=4e-12 P=8e-6
MM65_15 net69 vb4 vss sub sg13_lv_nmos w=1u l=1u m=1
RT380 vss sub ptap1 A=4e-12 P=8e-6
MM65_16 net69 vb4 vss sub sg13_lv_nmos w=1u l=1u m=1
RT381 vss sub ptap1 A=4e-12 P=8e-6
MM65_17 net69 vb4 vss sub sg13_lv_nmos w=1u l=1u m=1
RT382 vss sub ptap1 A=4e-12 P=8e-6
MM65_18 net69 vb4 vss sub sg13_lv_nmos w=1u l=1u m=1
RT383 vss sub ptap1 A=4e-12 P=8e-6
MM65_19 net69 vb4 vss sub sg13_lv_nmos w=1u l=1u m=1
RT384 vss sub ptap1 A=4e-12 P=8e-6
MM65_20 net69 vb4 vss sub sg13_lv_nmos w=1u l=1u m=1
RT385 vss sub ptap1 A=4e-12 P=8e-6
MM65_21 net69 vb4 vss sub sg13_lv_nmos w=1u l=1u m=1
RT386 vss sub ptap1 A=4e-12 P=8e-6
MM65_22 net69 vb4 vss sub sg13_lv_nmos w=1u l=1u m=1
RT387 vss sub ptap1 A=4e-12 P=8e-6
MM65_23 net69 vb4 vss sub sg13_lv_nmos w=1u l=1u m=1
RT388 vss sub ptap1 A=4e-12 P=8e-6
MM65_24 net69 vb4 vss sub sg13_lv_nmos w=1u l=1u m=1
RT389 vss sub ptap1 A=4e-12 P=8e-6
MM65_25 net69 vb4 vss sub sg13_lv_nmos w=1u l=1u m=1
RT390 vss sub ptap1 A=4e-12 P=8e-6
MM65_26 net69 vb4 vss sub sg13_lv_nmos w=1u l=1u m=1
RT391 vss sub ptap1 A=4e-12 P=8e-6
MM65_27 net69 vb4 vss sub sg13_lv_nmos w=1u l=1u m=1
RT392 vss sub ptap1 A=4e-12 P=8e-6
MM65_28 net69 vb4 vss sub sg13_lv_nmos w=1u l=1u m=1
RT393 vss sub ptap1 A=4e-12 P=8e-6
MM65_29 net69 vb4 vss sub sg13_lv_nmos w=1u l=1u m=1
RT394 vss sub ptap1 A=4e-12 P=8e-6
MM65_30 net69 vb4 vss sub sg13_lv_nmos w=1u l=1u m=1
RT395 vss sub ptap1 A=4e-12 P=8e-6
MM65_31 net69 vb4 vss sub sg13_lv_nmos w=1u l=1u m=1
RT396 vdd well_396 ntap1 A=4e-12 P=8e-6
MM68_0 net2 net70 vdd well_396 sg13_lv_pmos w=1u l=1u m=1
RT397 vdd well_397 ntap1 A=4e-12 P=8e-6
MM68_1 net2 net70 vdd well_397 sg13_lv_pmos w=1u l=1u m=1
RT398 vdd well_398 ntap1 A=4e-12 P=8e-6
MM68_2 net2 net70 vdd well_398 sg13_lv_pmos w=1u l=1u m=1
RT399 vdd well_399 ntap1 A=4e-12 P=8e-6
MM68_3 net2 net70 vdd well_399 sg13_lv_pmos w=1u l=1u m=1
RT400 vdd well_400 ntap1 A=4e-12 P=8e-6
MM68_4 net2 net70 vdd well_400 sg13_lv_pmos w=1u l=1u m=1
RT401 vdd well_401 ntap1 A=4e-12 P=8e-6
MM68_5 net2 net70 vdd well_401 sg13_lv_pmos w=1u l=1u m=1
RT402 vdd well_402 ntap1 A=4e-12 P=8e-6
MM68_6 net2 net70 vdd well_402 sg13_lv_pmos w=1u l=1u m=1
RT403 vdd well_403 ntap1 A=4e-12 P=8e-6
MM68_7 net2 net70 vdd well_403 sg13_lv_pmos w=1u l=1u m=1
RT404 vdd well_404 ntap1 A=4e-12 P=8e-6
MM68_8 net2 net70 vdd well_404 sg13_lv_pmos w=1u l=1u m=1
RT405 vdd well_405 ntap1 A=4e-12 P=8e-6
MM68_9 net2 net70 vdd well_405 sg13_lv_pmos w=1u l=1u m=1
RT406 vdd well_406 ntap1 A=4e-12 P=8e-6
MM68_10 net2 net70 vdd well_406 sg13_lv_pmos w=1u l=1u m=1
RT407 vdd well_407 ntap1 A=4e-12 P=8e-6
MM68_11 net2 net70 vdd well_407 sg13_lv_pmos w=1u l=1u m=1
RT408 vdd well_408 ntap1 A=4e-12 P=8e-6
MM68_12 net2 net70 vdd well_408 sg13_lv_pmos w=1u l=1u m=1
RT409 vdd well_409 ntap1 A=4e-12 P=8e-6
MM68_13 net2 net70 vdd well_409 sg13_lv_pmos w=1u l=1u m=1
RT410 vdd well_410 ntap1 A=4e-12 P=8e-6
MM68_14 net2 net70 vdd well_410 sg13_lv_pmos w=1u l=1u m=1
RT411 vdd well_411 ntap1 A=4e-12 P=8e-6
MM68_15 net2 net70 vdd well_411 sg13_lv_pmos w=1u l=1u m=1
RT412 vdd well_412 ntap1 A=4e-12 P=8e-6
MM69_0 net3 net70 vdd well_412 sg13_lv_pmos w=1u l=1u m=1
RT413 vdd well_413 ntap1 A=4e-12 P=8e-6
MM69_1 net3 net70 vdd well_413 sg13_lv_pmos w=1u l=1u m=1
RT414 vdd well_414 ntap1 A=4e-12 P=8e-6
MM69_2 net3 net70 vdd well_414 sg13_lv_pmos w=1u l=1u m=1
RT415 vdd well_415 ntap1 A=4e-12 P=8e-6
MM69_3 net3 net70 vdd well_415 sg13_lv_pmos w=1u l=1u m=1
RT416 vdd well_416 ntap1 A=4e-12 P=8e-6
MM69_4 net3 net70 vdd well_416 sg13_lv_pmos w=1u l=1u m=1
RT417 vdd well_417 ntap1 A=4e-12 P=8e-6
MM69_5 net3 net70 vdd well_417 sg13_lv_pmos w=1u l=1u m=1
RT418 vdd well_418 ntap1 A=4e-12 P=8e-6
MM69_6 net3 net70 vdd well_418 sg13_lv_pmos w=1u l=1u m=1
RT419 vdd well_419 ntap1 A=4e-12 P=8e-6
MM69_7 net3 net70 vdd well_419 sg13_lv_pmos w=1u l=1u m=1
RT420 vdd well_420 ntap1 A=4e-12 P=8e-6
MM69_8 net3 net70 vdd well_420 sg13_lv_pmos w=1u l=1u m=1
RT421 vdd well_421 ntap1 A=4e-12 P=8e-6
MM69_9 net3 net70 vdd well_421 sg13_lv_pmos w=1u l=1u m=1
RT422 vdd well_422 ntap1 A=4e-12 P=8e-6
MM69_10 net3 net70 vdd well_422 sg13_lv_pmos w=1u l=1u m=1
RT423 vdd well_423 ntap1 A=4e-12 P=8e-6
MM69_11 net3 net70 vdd well_423 sg13_lv_pmos w=1u l=1u m=1
RT424 vdd well_424 ntap1 A=4e-12 P=8e-6
MM69_12 net3 net70 vdd well_424 sg13_lv_pmos w=1u l=1u m=1
RT425 vdd well_425 ntap1 A=4e-12 P=8e-6
MM69_13 net3 net70 vdd well_425 sg13_lv_pmos w=1u l=1u m=1
RT426 vdd well_426 ntap1 A=4e-12 P=8e-6
MM69_14 net3 net70 vdd well_426 sg13_lv_pmos w=1u l=1u m=1
RT427 vdd well_427 ntap1 A=4e-12 P=8e-6
MM69_15 net3 net70 vdd well_427 sg13_lv_pmos w=1u l=1u m=1
RT428 vdd well_428 ntap1 A=4e-12 P=8e-6
MM7_0 net049 voutn vdd well_428 sg13_lv_pmos w=1u l=1u m=1
RT429 vdd well_429 ntap1 A=4e-12 P=8e-6
MM7_1 net049 voutn vdd well_429 sg13_lv_pmos w=1u l=1u m=1
RT430 vdd well_430 ntap1 A=4e-12 P=8e-6
MM7_2 net049 voutn vdd well_430 sg13_lv_pmos w=1u l=1u m=1
RT431 vdd well_431 ntap1 A=4e-12 P=8e-6
MM7_3 net049 voutn vdd well_431 sg13_lv_pmos w=1u l=1u m=1
RT432 vss sub ptap1 A=4e-12 P=8e-6
MM70_0 net70 vb3 net69 sub sg13_lv_nmos w=1u l=1u m=1
RT433 vss sub ptap1 A=4e-12 P=8e-6
MM70_1 net70 vb3 net69 sub sg13_lv_nmos w=1u l=1u m=1
RT434 vss sub ptap1 A=4e-12 P=8e-6
MM70_2 net70 vb3 net69 sub sg13_lv_nmos w=1u l=1u m=1
RT435 vss sub ptap1 A=4e-12 P=8e-6
MM70_3 net70 vb3 net69 sub sg13_lv_nmos w=1u l=1u m=1
RT436 vss sub ptap1 A=4e-12 P=8e-6
MM70_4 net70 vb3 net69 sub sg13_lv_nmos w=1u l=1u m=1
RT437 vss sub ptap1 A=4e-12 P=8e-6
MM70_5 net70 vb3 net69 sub sg13_lv_nmos w=1u l=1u m=1
RT438 vss sub ptap1 A=4e-12 P=8e-6
MM70_6 net70 vb3 net69 sub sg13_lv_nmos w=1u l=1u m=1
RT439 vss sub ptap1 A=4e-12 P=8e-6
MM70_7 net70 vb3 net69 sub sg13_lv_nmos w=1u l=1u m=1
RT440 vss sub ptap1 A=4e-12 P=8e-6
MM70_8 net70 vb3 net69 sub sg13_lv_nmos w=1u l=1u m=1
RT441 vss sub ptap1 A=4e-12 P=8e-6
MM70_9 net70 vb3 net69 sub sg13_lv_nmos w=1u l=1u m=1
RT442 vss sub ptap1 A=4e-12 P=8e-6
MM70_10 net70 vb3 net69 sub sg13_lv_nmos w=1u l=1u m=1
RT443 vss sub ptap1 A=4e-12 P=8e-6
MM70_11 net70 vb3 net69 sub sg13_lv_nmos w=1u l=1u m=1
RT444 vss sub ptap1 A=4e-12 P=8e-6
MM70_12 net70 vb3 net69 sub sg13_lv_nmos w=1u l=1u m=1
RT445 vss sub ptap1 A=4e-12 P=8e-6
MM70_13 net70 vb3 net69 sub sg13_lv_nmos w=1u l=1u m=1
RT446 vss sub ptap1 A=4e-12 P=8e-6
MM70_14 net70 vb3 net69 sub sg13_lv_nmos w=1u l=1u m=1
RT447 vss sub ptap1 A=4e-12 P=8e-6
MM70_15 net70 vb3 net69 sub sg13_lv_nmos w=1u l=1u m=1
RT448 vss sub ptap1 A=4e-12 P=8e-6
MM71_0 voutn vb3 net85 sub sg13_lv_nmos w=1u l=1u m=1
RT449 vss sub ptap1 A=4e-12 P=8e-6
MM71_1 voutn vb3 net85 sub sg13_lv_nmos w=1u l=1u m=1
RT450 vss sub ptap1 A=4e-12 P=8e-6
MM71_2 voutn vb3 net85 sub sg13_lv_nmos w=1u l=1u m=1
RT451 vss sub ptap1 A=4e-12 P=8e-6
MM71_3 voutn vb3 net85 sub sg13_lv_nmos w=1u l=1u m=1
RT452 vss sub ptap1 A=4e-12 P=8e-6
MM71_4 voutn vb3 net85 sub sg13_lv_nmos w=1u l=1u m=1
RT453 vss sub ptap1 A=4e-12 P=8e-6
MM71_5 voutn vb3 net85 sub sg13_lv_nmos w=1u l=1u m=1
RT454 vss sub ptap1 A=4e-12 P=8e-6
MM71_6 voutn vb3 net85 sub sg13_lv_nmos w=1u l=1u m=1
RT455 vss sub ptap1 A=4e-12 P=8e-6
MM71_7 voutn vb3 net85 sub sg13_lv_nmos w=1u l=1u m=1
RT456 vss sub ptap1 A=4e-12 P=8e-6
MM71_8 voutn vb3 net85 sub sg13_lv_nmos w=1u l=1u m=1
RT457 vss sub ptap1 A=4e-12 P=8e-6
MM71_9 voutn vb3 net85 sub sg13_lv_nmos w=1u l=1u m=1
RT458 vss sub ptap1 A=4e-12 P=8e-6
MM71_10 voutn vb3 net85 sub sg13_lv_nmos w=1u l=1u m=1
RT459 vss sub ptap1 A=4e-12 P=8e-6
MM71_11 voutn vb3 net85 sub sg13_lv_nmos w=1u l=1u m=1
RT460 vss sub ptap1 A=4e-12 P=8e-6
MM71_12 voutn vb3 net85 sub sg13_lv_nmos w=1u l=1u m=1
RT461 vss sub ptap1 A=4e-12 P=8e-6
MM71_13 voutn vb3 net85 sub sg13_lv_nmos w=1u l=1u m=1
RT462 vss sub ptap1 A=4e-12 P=8e-6
MM71_14 voutn vb3 net85 sub sg13_lv_nmos w=1u l=1u m=1
RT463 vss sub ptap1 A=4e-12 P=8e-6
MM71_15 voutn vb3 net85 sub sg13_lv_nmos w=1u l=1u m=1
RT464 net31 well_464 ntap1 A=4e-12 P=8e-6
MM8_0 dm_2 vinn net31 well_464 sg13_lv_pmos w=1u l=1u m=1
RT465 net31 well_465 ntap1 A=4e-12 P=8e-6
MM8_1 dm_2 vinn net31 well_465 sg13_lv_pmos w=1u l=1u m=1
RT466 net31 well_466 ntap1 A=4e-12 P=8e-6
MM8_2 dm_2 vinn net31 well_466 sg13_lv_pmos w=1u l=1u m=1
RT467 net31 well_467 ntap1 A=4e-12 P=8e-6
MM8_3 dm_2 vinn net31 well_467 sg13_lv_pmos w=1u l=1u m=1
RT468 net31 well_468 ntap1 A=4e-12 P=8e-6
MM9_0 net063 vinp net31 well_468 sg13_lv_pmos w=1u l=1u m=1
RT469 net31 well_469 ntap1 A=4e-12 P=8e-6
MM9_1 net063 vinp net31 well_469 sg13_lv_pmos w=1u l=1u m=1
RT470 net31 well_470 ntap1 A=4e-12 P=8e-6
MM9_2 net063 vinp net31 well_470 sg13_lv_pmos w=1u l=1u m=1
RT471 net31 well_471 ntap1 A=4e-12 P=8e-6
MM9_3 net063 vinp net31 well_471 sg13_lv_pmos w=1u l=1u m=1
RTSUB vss sub ptap1 A=4e-12 P=8e-6
C0_0 vout net70 cap_cmim w=31.57u l=31.57u m=1
C2_0 net4 vss cap_cmim w=21.55u l=21.55u m=1
.ends amp_016_song_dacfc
