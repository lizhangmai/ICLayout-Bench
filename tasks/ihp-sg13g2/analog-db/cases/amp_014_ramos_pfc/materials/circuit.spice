* Copyright 2026 Danial Noori Zadeh. See collection LICENSE and NOTICE.
* Fixed IHP binding; external bias ports and native physical taps.
.subckt amp_014_ramos_pfc vss vdd vinn vinp vout net1
XT0 vdd well_0 ntap1 A=4e-12 P=8e-6
XM0_0 net1 net1 vdd well_0 sg13_lv_pmos w=1u l=1u m=1
XT1 vdd well_1 ntap1 A=4e-12 P=8e-6
XM0_1 net1 net1 vdd well_1 sg13_lv_pmos w=1u l=1u m=1
XT2 vdd well_2 ntap1 A=4e-12 P=8e-6
XM0_2 net1 net1 vdd well_2 sg13_lv_pmos w=1u l=1u m=1
XT3 vdd well_3 ntap1 A=4e-12 P=8e-6
XM0_3 net1 net1 vdd well_3 sg13_lv_pmos w=1u l=1u m=1
XT4 vdd well_4 ntap1 A=4e-12 P=8e-6
XM0_4 net1 net1 vdd well_4 sg13_lv_pmos w=1u l=1u m=1
XT5 vdd well_5 ntap1 A=4e-12 P=8e-6
XM0_5 net1 net1 vdd well_5 sg13_lv_pmos w=1u l=1u m=1
XT6 vdd well_6 ntap1 A=4e-12 P=8e-6
XM0_6 net1 net1 vdd well_6 sg13_lv_pmos w=1u l=1u m=1
XT7 vdd well_7 ntap1 A=4e-12 P=8e-6
XM0_7 net1 net1 vdd well_7 sg13_lv_pmos w=1u l=1u m=1
XT8 vdd well_8 ntap1 A=4e-12 P=8e-6
XM0_8 net1 net1 vdd well_8 sg13_lv_pmos w=1u l=1u m=1
XT9 vdd well_9 ntap1 A=4e-12 P=8e-6
XM0_9 net1 net1 vdd well_9 sg13_lv_pmos w=1u l=1u m=1
XT10 vdd well_10 ntap1 A=4e-12 P=8e-6
XM0_10 net1 net1 vdd well_10 sg13_lv_pmos w=1u l=1u m=1
XT11 vdd well_11 ntap1 A=4e-12 P=8e-6
XM0_11 net1 net1 vdd well_11 sg13_lv_pmos w=1u l=1u m=1
XT12 vdd well_12 ntap1 A=4e-12 P=8e-6
XM0_12 net1 net1 vdd well_12 sg13_lv_pmos w=1u l=1u m=1
XT13 vdd well_13 ntap1 A=4e-12 P=8e-6
XM0_13 net1 net1 vdd well_13 sg13_lv_pmos w=1u l=1u m=1
XT14 vdd well_14 ntap1 A=4e-12 P=8e-6
XM0_14 net1 net1 vdd well_14 sg13_lv_pmos w=1u l=1u m=1
XT15 vdd well_15 ntap1 A=4e-12 P=8e-6
XM0_15 net1 net1 vdd well_15 sg13_lv_pmos w=1u l=1u m=1
XT16 vdd well_16 ntap1 A=4e-12 P=8e-6
XM0_16 net1 net1 vdd well_16 sg13_lv_pmos w=1u l=1u m=1
XT17 vdd well_17 ntap1 A=4e-12 P=8e-6
XM0_17 net1 net1 vdd well_17 sg13_lv_pmos w=1u l=1u m=1
XT18 vdd well_18 ntap1 A=4e-12 P=8e-6
XM0_18 net1 net1 vdd well_18 sg13_lv_pmos w=1u l=1u m=1
XT19 vdd well_19 ntap1 A=4e-12 P=8e-6
XM0_19 net1 net1 vdd well_19 sg13_lv_pmos w=1u l=1u m=1
XT20 vdd well_20 ntap1 A=4e-12 P=8e-6
XM0_20 net1 net1 vdd well_20 sg13_lv_pmos w=1u l=1u m=1
XT21 vdd well_21 ntap1 A=4e-12 P=8e-6
XM0_21 net1 net1 vdd well_21 sg13_lv_pmos w=1u l=1u m=1
XT22 vdd well_22 ntap1 A=4e-12 P=8e-6
XM0_22 net1 net1 vdd well_22 sg13_lv_pmos w=1u l=1u m=1
XT23 vdd well_23 ntap1 A=4e-12 P=8e-6
XM0_23 net1 net1 vdd well_23 sg13_lv_pmos w=1u l=1u m=1
XT24 vdd well_24 ntap1 A=4e-12 P=8e-6
XM0_24 net1 net1 vdd well_24 sg13_lv_pmos w=1u l=1u m=1
XT25 vdd well_25 ntap1 A=4e-12 P=8e-6
XM0_25 net1 net1 vdd well_25 sg13_lv_pmos w=1u l=1u m=1
XT26 vdd well_26 ntap1 A=4e-12 P=8e-6
XM0_26 net1 net1 vdd well_26 sg13_lv_pmos w=1u l=1u m=1
XT27 vdd well_27 ntap1 A=4e-12 P=8e-6
XM0_27 net1 net1 vdd well_27 sg13_lv_pmos w=1u l=1u m=1
XT28 vdd well_28 ntap1 A=4e-12 P=8e-6
XM0_28 net1 net1 vdd well_28 sg13_lv_pmos w=1u l=1u m=1
XT29 vdd well_29 ntap1 A=4e-12 P=8e-6
XM0_29 net1 net1 vdd well_29 sg13_lv_pmos w=1u l=1u m=1
XT30 vdd well_30 ntap1 A=4e-12 P=8e-6
XM0_30 net1 net1 vdd well_30 sg13_lv_pmos w=1u l=1u m=1
XT31 vdd well_31 ntap1 A=4e-12 P=8e-6
XM0_31 net1 net1 vdd well_31 sg13_lv_pmos w=1u l=1u m=1
XT32 vdd well_32 ntap1 A=4e-12 P=8e-6
XM0_32 net1 net1 vdd well_32 sg13_lv_pmos w=1u l=1u m=1
XT33 vdd well_33 ntap1 A=4e-12 P=8e-6
XM0_33 net1 net1 vdd well_33 sg13_lv_pmos w=1u l=1u m=1
XT34 vdd well_34 ntap1 A=4e-12 P=8e-6
XM0_34 net1 net1 vdd well_34 sg13_lv_pmos w=1u l=1u m=1
XT35 vdd well_35 ntap1 A=4e-12 P=8e-6
XM0_35 net1 net1 vdd well_35 sg13_lv_pmos w=1u l=1u m=1
XT36 vdd well_36 ntap1 A=4e-12 P=8e-6
XM0_36 net1 net1 vdd well_36 sg13_lv_pmos w=1u l=1u m=1
XT37 vdd well_37 ntap1 A=4e-12 P=8e-6
XM0_37 net1 net1 vdd well_37 sg13_lv_pmos w=1u l=1u m=1
XT38 vdd well_38 ntap1 A=4e-12 P=8e-6
XM0_38 net1 net1 vdd well_38 sg13_lv_pmos w=1u l=1u m=1
XT39 vdd well_39 ntap1 A=4e-12 P=8e-6
XM0_39 net1 net1 vdd well_39 sg13_lv_pmos w=1u l=1u m=1
XT40 vdd well_40 ntap1 A=4e-12 P=8e-6
XM0_40 net1 net1 vdd well_40 sg13_lv_pmos w=1u l=1u m=1
XT41 vdd well_41 ntap1 A=4e-12 P=8e-6
XM0_41 net1 net1 vdd well_41 sg13_lv_pmos w=1u l=1u m=1
XT42 vdd well_42 ntap1 A=4e-12 P=8e-6
XM0_42 net1 net1 vdd well_42 sg13_lv_pmos w=1u l=1u m=1
XT43 vdd well_43 ntap1 A=4e-12 P=8e-6
XM0_43 net1 net1 vdd well_43 sg13_lv_pmos w=1u l=1u m=1
XT44 vdd well_44 ntap1 A=4e-12 P=8e-6
XM0_44 net1 net1 vdd well_44 sg13_lv_pmos w=1u l=1u m=1
XT45 vdd well_45 ntap1 A=4e-12 P=8e-6
XM0_45 net1 net1 vdd well_45 sg13_lv_pmos w=1u l=1u m=1
XT46 vdd well_46 ntap1 A=4e-12 P=8e-6
XM0_46 net1 net1 vdd well_46 sg13_lv_pmos w=1u l=1u m=1
XT47 vdd well_47 ntap1 A=4e-12 P=8e-6
XM0_47 net1 net1 vdd well_47 sg13_lv_pmos w=1u l=1u m=1
XT48 vdd well_48 ntap1 A=4e-12 P=8e-6
XM0_48 net1 net1 vdd well_48 sg13_lv_pmos w=1u l=1u m=1
XT49 vdd well_49 ntap1 A=4e-12 P=8e-6
XM0_49 net1 net1 vdd well_49 sg13_lv_pmos w=1u l=1u m=1
XT50 vdd well_50 ntap1 A=4e-12 P=8e-6
XM0_50 net1 net1 vdd well_50 sg13_lv_pmos w=1u l=1u m=1
XT51 vdd well_51 ntap1 A=4e-12 P=8e-6
XM0_51 net1 net1 vdd well_51 sg13_lv_pmos w=1u l=1u m=1
XT52 vdd well_52 ntap1 A=4e-12 P=8e-6
XM0_52 net1 net1 vdd well_52 sg13_lv_pmos w=1u l=1u m=1
XT53 vdd well_53 ntap1 A=4e-12 P=8e-6
XM0_53 net1 net1 vdd well_53 sg13_lv_pmos w=1u l=1u m=1
XT54 vdd well_54 ntap1 A=4e-12 P=8e-6
XM0_54 net1 net1 vdd well_54 sg13_lv_pmos w=1u l=1u m=1
XT55 vdd well_55 ntap1 A=4e-12 P=8e-6
XM0_55 net1 net1 vdd well_55 sg13_lv_pmos w=1u l=1u m=1
XT56 vdd well_56 ntap1 A=4e-12 P=8e-6
XM0_56 net1 net1 vdd well_56 sg13_lv_pmos w=1u l=1u m=1
XT57 vdd well_57 ntap1 A=4e-12 P=8e-6
XM0_57 net1 net1 vdd well_57 sg13_lv_pmos w=1u l=1u m=1
XT58 vdd well_58 ntap1 A=4e-12 P=8e-6
XM0_58 net1 net1 vdd well_58 sg13_lv_pmos w=1u l=1u m=1
XT59 vdd well_59 ntap1 A=4e-12 P=8e-6
XM0_59 net1 net1 vdd well_59 sg13_lv_pmos w=1u l=1u m=1
XT60 vdd well_60 ntap1 A=4e-12 P=8e-6
XM0_60 net1 net1 vdd well_60 sg13_lv_pmos w=1u l=1u m=1
XT61 vdd well_61 ntap1 A=4e-12 P=8e-6
XM0_61 net1 net1 vdd well_61 sg13_lv_pmos w=1u l=1u m=1
XT62 vdd well_62 ntap1 A=4e-12 P=8e-6
XM0_62 net1 net1 vdd well_62 sg13_lv_pmos w=1u l=1u m=1
XT63 vdd well_63 ntap1 A=4e-12 P=8e-6
XM0_63 net1 net1 vdd well_63 sg13_lv_pmos w=1u l=1u m=1
XT64 vdd well_64 ntap1 A=4e-12 P=8e-6
XM0_64 net1 net1 vdd well_64 sg13_lv_pmos w=1u l=1u m=1
XT65 vdd well_65 ntap1 A=4e-12 P=8e-6
XM0_65 net1 net1 vdd well_65 sg13_lv_pmos w=1u l=1u m=1
XT66 vdd well_66 ntap1 A=4e-12 P=8e-6
XM0_66 net1 net1 vdd well_66 sg13_lv_pmos w=1u l=1u m=1
XT67 vdd well_67 ntap1 A=4e-12 P=8e-6
XM0_67 net1 net1 vdd well_67 sg13_lv_pmos w=1u l=1u m=1
XT68 vdd well_68 ntap1 A=4e-12 P=8e-6
XM0_68 net1 net1 vdd well_68 sg13_lv_pmos w=1u l=1u m=1
XT69 vdd well_69 ntap1 A=4e-12 P=8e-6
XM0_69 net1 net1 vdd well_69 sg13_lv_pmos w=1u l=1u m=1
XT70 vdd well_70 ntap1 A=4e-12 P=8e-6
XM0_70 net1 net1 vdd well_70 sg13_lv_pmos w=1u l=1u m=1
XT71 vdd well_71 ntap1 A=4e-12 P=8e-6
XM1_0 vb4 net1 vdd well_71 sg13_lv_pmos w=1u l=1u m=1
XT72 vdd well_72 ntap1 A=4e-12 P=8e-6
XM1_1 vb4 net1 vdd well_72 sg13_lv_pmos w=1u l=1u m=1
XT73 vdd well_73 ntap1 A=4e-12 P=8e-6
XM1_2 vb4 net1 vdd well_73 sg13_lv_pmos w=1u l=1u m=1
XT74 vdd well_74 ntap1 A=4e-12 P=8e-6
XM1_3 vb4 net1 vdd well_74 sg13_lv_pmos w=1u l=1u m=1
XT75 vdd well_75 ntap1 A=4e-12 P=8e-6
XM1_4 vb4 net1 vdd well_75 sg13_lv_pmos w=1u l=1u m=1
XT76 vdd well_76 ntap1 A=4e-12 P=8e-6
XM1_5 vb4 net1 vdd well_76 sg13_lv_pmos w=1u l=1u m=1
XT77 vdd well_77 ntap1 A=4e-12 P=8e-6
XM1_6 vb4 net1 vdd well_77 sg13_lv_pmos w=1u l=1u m=1
XT78 vdd well_78 ntap1 A=4e-12 P=8e-6
XM1_7 vb4 net1 vdd well_78 sg13_lv_pmos w=1u l=1u m=1
XT79 vdd well_79 ntap1 A=4e-12 P=8e-6
XM1_8 vb4 net1 vdd well_79 sg13_lv_pmos w=1u l=1u m=1
XT80 vdd well_80 ntap1 A=4e-12 P=8e-6
XM1_9 vb4 net1 vdd well_80 sg13_lv_pmos w=1u l=1u m=1
XT81 vdd well_81 ntap1 A=4e-12 P=8e-6
XM1_10 vb4 net1 vdd well_81 sg13_lv_pmos w=1u l=1u m=1
XT82 vdd well_82 ntap1 A=4e-12 P=8e-6
XM1_11 vb4 net1 vdd well_82 sg13_lv_pmos w=1u l=1u m=1
XT83 vdd well_83 ntap1 A=4e-12 P=8e-6
XM1_12 vb4 net1 vdd well_83 sg13_lv_pmos w=1u l=1u m=1
XT84 vdd well_84 ntap1 A=4e-12 P=8e-6
XM1_13 vb4 net1 vdd well_84 sg13_lv_pmos w=1u l=1u m=1
XT85 vdd well_85 ntap1 A=4e-12 P=8e-6
XM1_14 vb4 net1 vdd well_85 sg13_lv_pmos w=1u l=1u m=1
XT86 vdd well_86 ntap1 A=4e-12 P=8e-6
XM1_15 vb4 net1 vdd well_86 sg13_lv_pmos w=1u l=1u m=1
XT87 vdd well_87 ntap1 A=4e-12 P=8e-6
XM1_16 vb4 net1 vdd well_87 sg13_lv_pmos w=1u l=1u m=1
XT88 vdd well_88 ntap1 A=4e-12 P=8e-6
XM1_17 vb4 net1 vdd well_88 sg13_lv_pmos w=1u l=1u m=1
XT89 vdd well_89 ntap1 A=4e-12 P=8e-6
XM1_18 vb4 net1 vdd well_89 sg13_lv_pmos w=1u l=1u m=1
XT90 vdd well_90 ntap1 A=4e-12 P=8e-6
XM1_19 vb4 net1 vdd well_90 sg13_lv_pmos w=1u l=1u m=1
XT91 vdd well_91 ntap1 A=4e-12 P=8e-6
XM1_20 vb4 net1 vdd well_91 sg13_lv_pmos w=1u l=1u m=1
XT92 vdd well_92 ntap1 A=4e-12 P=8e-6
XM1_21 vb4 net1 vdd well_92 sg13_lv_pmos w=1u l=1u m=1
XT93 vdd well_93 ntap1 A=4e-12 P=8e-6
XM1_22 vb4 net1 vdd well_93 sg13_lv_pmos w=1u l=1u m=1
XT94 vdd well_94 ntap1 A=4e-12 P=8e-6
XM1_23 vb4 net1 vdd well_94 sg13_lv_pmos w=1u l=1u m=1
XT95 vdd well_95 ntap1 A=4e-12 P=8e-6
XM1_24 vb4 net1 vdd well_95 sg13_lv_pmos w=1u l=1u m=1
XT96 vdd well_96 ntap1 A=4e-12 P=8e-6
XM1_25 vb4 net1 vdd well_96 sg13_lv_pmos w=1u l=1u m=1
XT97 vdd well_97 ntap1 A=4e-12 P=8e-6
XM1_26 vb4 net1 vdd well_97 sg13_lv_pmos w=1u l=1u m=1
XT98 vdd well_98 ntap1 A=4e-12 P=8e-6
XM1_27 vb4 net1 vdd well_98 sg13_lv_pmos w=1u l=1u m=1
XT99 vdd well_99 ntap1 A=4e-12 P=8e-6
XM1_28 vb4 net1 vdd well_99 sg13_lv_pmos w=1u l=1u m=1
XT100 vdd well_100 ntap1 A=4e-12 P=8e-6
XM1_29 vb4 net1 vdd well_100 sg13_lv_pmos w=1u l=1u m=1
XT101 vdd well_101 ntap1 A=4e-12 P=8e-6
XM1_30 vb4 net1 vdd well_101 sg13_lv_pmos w=1u l=1u m=1
XT102 vdd well_102 ntap1 A=4e-12 P=8e-6
XM1_31 vb4 net1 vdd well_102 sg13_lv_pmos w=1u l=1u m=1
XT103 vdd well_103 ntap1 A=4e-12 P=8e-6
XM1_32 vb4 net1 vdd well_103 sg13_lv_pmos w=1u l=1u m=1
XT104 vdd well_104 ntap1 A=4e-12 P=8e-6
XM1_33 vb4 net1 vdd well_104 sg13_lv_pmos w=1u l=1u m=1
XT105 vdd well_105 ntap1 A=4e-12 P=8e-6
XM1_34 vb4 net1 vdd well_105 sg13_lv_pmos w=1u l=1u m=1
XT106 vdd well_106 ntap1 A=4e-12 P=8e-6
XM1_35 vb4 net1 vdd well_106 sg13_lv_pmos w=1u l=1u m=1
XT107 vdd well_107 ntap1 A=4e-12 P=8e-6
XM1_36 vb4 net1 vdd well_107 sg13_lv_pmos w=1u l=1u m=1
XT108 vdd well_108 ntap1 A=4e-12 P=8e-6
XM1_37 vb4 net1 vdd well_108 sg13_lv_pmos w=1u l=1u m=1
XT109 vdd well_109 ntap1 A=4e-12 P=8e-6
XM1_38 vb4 net1 vdd well_109 sg13_lv_pmos w=1u l=1u m=1
XT110 vdd well_110 ntap1 A=4e-12 P=8e-6
XM1_39 vb4 net1 vdd well_110 sg13_lv_pmos w=1u l=1u m=1
XT111 vdd well_111 ntap1 A=4e-12 P=8e-6
XM1_40 vb4 net1 vdd well_111 sg13_lv_pmos w=1u l=1u m=1
XT112 vdd well_112 ntap1 A=4e-12 P=8e-6
XM1_41 vb4 net1 vdd well_112 sg13_lv_pmos w=1u l=1u m=1
XT113 vdd well_113 ntap1 A=4e-12 P=8e-6
XM1_42 vb4 net1 vdd well_113 sg13_lv_pmos w=1u l=1u m=1
XT114 vdd well_114 ntap1 A=4e-12 P=8e-6
XM1_43 vb4 net1 vdd well_114 sg13_lv_pmos w=1u l=1u m=1
XT115 vdd well_115 ntap1 A=4e-12 P=8e-6
XM1_44 vb4 net1 vdd well_115 sg13_lv_pmos w=1u l=1u m=1
XT116 vdd well_116 ntap1 A=4e-12 P=8e-6
XM1_45 vb4 net1 vdd well_116 sg13_lv_pmos w=1u l=1u m=1
XT117 vdd well_117 ntap1 A=4e-12 P=8e-6
XM1_46 vb4 net1 vdd well_117 sg13_lv_pmos w=1u l=1u m=1
XT118 vdd well_118 ntap1 A=4e-12 P=8e-6
XM1_47 vb4 net1 vdd well_118 sg13_lv_pmos w=1u l=1u m=1
XT119 vdd well_119 ntap1 A=4e-12 P=8e-6
XM1_48 vb4 net1 vdd well_119 sg13_lv_pmos w=1u l=1u m=1
XT120 vdd well_120 ntap1 A=4e-12 P=8e-6
XM1_49 vb4 net1 vdd well_120 sg13_lv_pmos w=1u l=1u m=1
XT121 vdd well_121 ntap1 A=4e-12 P=8e-6
XM1_50 vb4 net1 vdd well_121 sg13_lv_pmos w=1u l=1u m=1
XT122 vdd well_122 ntap1 A=4e-12 P=8e-6
XM1_51 vb4 net1 vdd well_122 sg13_lv_pmos w=1u l=1u m=1
XT123 vdd well_123 ntap1 A=4e-12 P=8e-6
XM1_52 vb4 net1 vdd well_123 sg13_lv_pmos w=1u l=1u m=1
XT124 vdd well_124 ntap1 A=4e-12 P=8e-6
XM1_53 vb4 net1 vdd well_124 sg13_lv_pmos w=1u l=1u m=1
XT125 vdd well_125 ntap1 A=4e-12 P=8e-6
XM1_54 vb4 net1 vdd well_125 sg13_lv_pmos w=1u l=1u m=1
XT126 vdd well_126 ntap1 A=4e-12 P=8e-6
XM1_55 vb4 net1 vdd well_126 sg13_lv_pmos w=1u l=1u m=1
XT127 vdd well_127 ntap1 A=4e-12 P=8e-6
XM1_56 vb4 net1 vdd well_127 sg13_lv_pmos w=1u l=1u m=1
XT128 vdd well_128 ntap1 A=4e-12 P=8e-6
XM1_57 vb4 net1 vdd well_128 sg13_lv_pmos w=1u l=1u m=1
XT129 vdd well_129 ntap1 A=4e-12 P=8e-6
XM1_58 vb4 net1 vdd well_129 sg13_lv_pmos w=1u l=1u m=1
XT130 vdd well_130 ntap1 A=4e-12 P=8e-6
XM1_59 vb4 net1 vdd well_130 sg13_lv_pmos w=1u l=1u m=1
XT131 vdd well_131 ntap1 A=4e-12 P=8e-6
XM1_60 vb4 net1 vdd well_131 sg13_lv_pmos w=1u l=1u m=1
XT132 vdd well_132 ntap1 A=4e-12 P=8e-6
XM1_61 vb4 net1 vdd well_132 sg13_lv_pmos w=1u l=1u m=1
XT133 vdd well_133 ntap1 A=4e-12 P=8e-6
XM1_62 vb4 net1 vdd well_133 sg13_lv_pmos w=1u l=1u m=1
XT134 vdd well_134 ntap1 A=4e-12 P=8e-6
XM1_63 vb4 net1 vdd well_134 sg13_lv_pmos w=1u l=1u m=1
XT135 vdd well_135 ntap1 A=4e-12 P=8e-6
XM1_64 vb4 net1 vdd well_135 sg13_lv_pmos w=1u l=1u m=1
XT136 vdd well_136 ntap1 A=4e-12 P=8e-6
XM1_65 vb4 net1 vdd well_136 sg13_lv_pmos w=1u l=1u m=1
XT137 vdd well_137 ntap1 A=4e-12 P=8e-6
XM1_66 vb4 net1 vdd well_137 sg13_lv_pmos w=1u l=1u m=1
XT138 vdd well_138 ntap1 A=4e-12 P=8e-6
XM1_67 vb4 net1 vdd well_138 sg13_lv_pmos w=1u l=1u m=1
XT139 vdd well_139 ntap1 A=4e-12 P=8e-6
XM1_68 vb4 net1 vdd well_139 sg13_lv_pmos w=1u l=1u m=1
XT140 vdd well_140 ntap1 A=4e-12 P=8e-6
XM1_69 vb4 net1 vdd well_140 sg13_lv_pmos w=1u l=1u m=1
XT141 vdd well_141 ntap1 A=4e-12 P=8e-6
XM1_70 vb4 net1 vdd well_141 sg13_lv_pmos w=1u l=1u m=1
XT142 vdd well_142 ntap1 A=4e-12 P=8e-6
XM10_0 net043 net050 vdd well_142 sg13_lv_pmos w=1u l=1u m=1
XT143 vdd well_143 ntap1 A=4e-12 P=8e-6
XM10_1 net043 net050 vdd well_143 sg13_lv_pmos w=1u l=1u m=1
XT144 vdd well_144 ntap1 A=4e-12 P=8e-6
XM10_2 net043 net050 vdd well_144 sg13_lv_pmos w=1u l=1u m=1
XT145 vdd well_145 ntap1 A=4e-12 P=8e-6
XM10_3 net043 net050 vdd well_145 sg13_lv_pmos w=1u l=1u m=1
XT146 vdd well_146 ntap1 A=4e-12 P=8e-6
XM10_4 net043 net050 vdd well_146 sg13_lv_pmos w=1u l=1u m=1
XT147 vdd well_147 ntap1 A=4e-12 P=8e-6
XM10_5 net043 net050 vdd well_147 sg13_lv_pmos w=1u l=1u m=1
XT148 vdd well_148 ntap1 A=4e-12 P=8e-6
XM10_6 net043 net050 vdd well_148 sg13_lv_pmos w=1u l=1u m=1
XT149 vdd well_149 ntap1 A=4e-12 P=8e-6
XM10_7 net043 net050 vdd well_149 sg13_lv_pmos w=1u l=1u m=1
XT150 vdd well_150 ntap1 A=4e-12 P=8e-6
XM10_8 net043 net050 vdd well_150 sg13_lv_pmos w=1u l=1u m=1
XT151 vdd well_151 ntap1 A=4e-12 P=8e-6
XM10_9 net043 net050 vdd well_151 sg13_lv_pmos w=1u l=1u m=1
XT152 vdd well_152 ntap1 A=4e-12 P=8e-6
XM10_10 net043 net050 vdd well_152 sg13_lv_pmos w=1u l=1u m=1
XT153 vdd well_153 ntap1 A=4e-12 P=8e-6
XM10_11 net043 net050 vdd well_153 sg13_lv_pmos w=1u l=1u m=1
XT154 vdd well_154 ntap1 A=4e-12 P=8e-6
XM10_12 net043 net050 vdd well_154 sg13_lv_pmos w=1u l=1u m=1
XT155 vdd well_155 ntap1 A=4e-12 P=8e-6
XM10_13 net043 net050 vdd well_155 sg13_lv_pmos w=1u l=1u m=1
XT156 vdd well_156 ntap1 A=4e-12 P=8e-6
XM10_14 net043 net050 vdd well_156 sg13_lv_pmos w=1u l=1u m=1
XT157 vdd well_157 ntap1 A=4e-12 P=8e-6
XM10_15 net043 net050 vdd well_157 sg13_lv_pmos w=1u l=1u m=1
XT158 vdd well_158 ntap1 A=4e-12 P=8e-6
XM10_16 net043 net050 vdd well_158 sg13_lv_pmos w=1u l=1u m=1
XT159 vdd well_159 ntap1 A=4e-12 P=8e-6
XM10_17 net043 net050 vdd well_159 sg13_lv_pmos w=1u l=1u m=1
XT160 vdd well_160 ntap1 A=4e-12 P=8e-6
XM10_18 net043 net050 vdd well_160 sg13_lv_pmos w=1u l=1u m=1
XT161 vdd well_161 ntap1 A=4e-12 P=8e-6
XM10_19 net043 net050 vdd well_161 sg13_lv_pmos w=1u l=1u m=1
XT162 vdd well_162 ntap1 A=4e-12 P=8e-6
XM10_20 net043 net050 vdd well_162 sg13_lv_pmos w=1u l=1u m=1
XT163 vdd well_163 ntap1 A=4e-12 P=8e-6
XM10_21 net043 net050 vdd well_163 sg13_lv_pmos w=1u l=1u m=1
XT164 vdd well_164 ntap1 A=4e-12 P=8e-6
XM10_22 net043 net050 vdd well_164 sg13_lv_pmos w=1u l=1u m=1
XT165 vdd well_165 ntap1 A=4e-12 P=8e-6
XM10_23 net043 net050 vdd well_165 sg13_lv_pmos w=1u l=1u m=1
XT166 vdd well_166 ntap1 A=4e-12 P=8e-6
XM10_24 net043 net050 vdd well_166 sg13_lv_pmos w=1u l=1u m=1
XT167 vdd well_167 ntap1 A=4e-12 P=8e-6
XM10_25 net043 net050 vdd well_167 sg13_lv_pmos w=1u l=1u m=1
XT168 vdd well_168 ntap1 A=4e-12 P=8e-6
XM10_26 net043 net050 vdd well_168 sg13_lv_pmos w=1u l=1u m=1
XT169 vdd well_169 ntap1 A=4e-12 P=8e-6
XM10_27 net043 net050 vdd well_169 sg13_lv_pmos w=1u l=1u m=1
XT170 vdd well_170 ntap1 A=4e-12 P=8e-6
XM10_28 net043 net050 vdd well_170 sg13_lv_pmos w=1u l=1u m=1
XT171 vdd well_171 ntap1 A=4e-12 P=8e-6
XM10_29 net043 net050 vdd well_171 sg13_lv_pmos w=1u l=1u m=1
XT172 vdd well_172 ntap1 A=4e-12 P=8e-6
XM10_30 net043 net050 vdd well_172 sg13_lv_pmos w=1u l=1u m=1
XT173 vdd well_173 ntap1 A=4e-12 P=8e-6
XM10_31 net043 net050 vdd well_173 sg13_lv_pmos w=1u l=1u m=1
XT174 vdd well_174 ntap1 A=4e-12 P=8e-6
XM10_32 net043 net050 vdd well_174 sg13_lv_pmos w=1u l=1u m=1
XT175 vdd well_175 ntap1 A=4e-12 P=8e-6
XM10_33 net043 net050 vdd well_175 sg13_lv_pmos w=1u l=1u m=1
XT176 vdd well_176 ntap1 A=4e-12 P=8e-6
XM10_34 net043 net050 vdd well_176 sg13_lv_pmos w=1u l=1u m=1
XT177 vdd well_177 ntap1 A=4e-12 P=8e-6
XM10_35 net043 net050 vdd well_177 sg13_lv_pmos w=1u l=1u m=1
XT178 vdd well_178 ntap1 A=4e-12 P=8e-6
XM10_36 net043 net050 vdd well_178 sg13_lv_pmos w=1u l=1u m=1
XT179 vdd well_179 ntap1 A=4e-12 P=8e-6
XM10_37 net043 net050 vdd well_179 sg13_lv_pmos w=1u l=1u m=1
XT180 vdd well_180 ntap1 A=4e-12 P=8e-6
XM10_38 net043 net050 vdd well_180 sg13_lv_pmos w=1u l=1u m=1
XT181 vdd well_181 ntap1 A=4e-12 P=8e-6
XM10_39 net043 net050 vdd well_181 sg13_lv_pmos w=1u l=1u m=1
XT182 vdd well_182 ntap1 A=4e-12 P=8e-6
XM10_40 net043 net050 vdd well_182 sg13_lv_pmos w=1u l=1u m=1
XT183 vdd well_183 ntap1 A=4e-12 P=8e-6
XM10_41 net043 net050 vdd well_183 sg13_lv_pmos w=1u l=1u m=1
XT184 vdd well_184 ntap1 A=4e-12 P=8e-6
XM10_42 net043 net050 vdd well_184 sg13_lv_pmos w=1u l=1u m=1
XT185 vdd well_185 ntap1 A=4e-12 P=8e-6
XM10_43 net043 net050 vdd well_185 sg13_lv_pmos w=1u l=1u m=1
XT186 vdd well_186 ntap1 A=4e-12 P=8e-6
XM10_44 net043 net050 vdd well_186 sg13_lv_pmos w=1u l=1u m=1
XT187 vdd well_187 ntap1 A=4e-12 P=8e-6
XM10_45 net043 net050 vdd well_187 sg13_lv_pmos w=1u l=1u m=1
XT188 vdd well_188 ntap1 A=4e-12 P=8e-6
XM10_46 net043 net050 vdd well_188 sg13_lv_pmos w=1u l=1u m=1
XT189 vdd well_189 ntap1 A=4e-12 P=8e-6
XM10_47 net043 net050 vdd well_189 sg13_lv_pmos w=1u l=1u m=1
XT190 vdd well_190 ntap1 A=4e-12 P=8e-6
XM10_48 net043 net050 vdd well_190 sg13_lv_pmos w=1u l=1u m=1
XT191 vdd well_191 ntap1 A=4e-12 P=8e-6
XM10_49 net043 net050 vdd well_191 sg13_lv_pmos w=1u l=1u m=1
XT192 vdd well_192 ntap1 A=4e-12 P=8e-6
XM10_50 net043 net050 vdd well_192 sg13_lv_pmos w=1u l=1u m=1
XT193 vdd well_193 ntap1 A=4e-12 P=8e-6
XM10_51 net043 net050 vdd well_193 sg13_lv_pmos w=1u l=1u m=1
XT194 vdd well_194 ntap1 A=4e-12 P=8e-6
XM10_52 net043 net050 vdd well_194 sg13_lv_pmos w=1u l=1u m=1
XT195 vdd well_195 ntap1 A=4e-12 P=8e-6
XM10_53 net043 net050 vdd well_195 sg13_lv_pmos w=1u l=1u m=1
XT196 vdd well_196 ntap1 A=4e-12 P=8e-6
XM10_54 net043 net050 vdd well_196 sg13_lv_pmos w=1u l=1u m=1
XT197 vdd well_197 ntap1 A=4e-12 P=8e-6
XM10_55 net043 net050 vdd well_197 sg13_lv_pmos w=1u l=1u m=1
XT198 vdd well_198 ntap1 A=4e-12 P=8e-6
XM10_56 net043 net050 vdd well_198 sg13_lv_pmos w=1u l=1u m=1
XT199 vdd well_199 ntap1 A=4e-12 P=8e-6
XM10_57 net043 net050 vdd well_199 sg13_lv_pmos w=1u l=1u m=1
XT200 vdd well_200 ntap1 A=4e-12 P=8e-6
XM10_58 net043 net050 vdd well_200 sg13_lv_pmos w=1u l=1u m=1
XT201 vdd well_201 ntap1 A=4e-12 P=8e-6
XM10_59 net043 net050 vdd well_201 sg13_lv_pmos w=1u l=1u m=1
XT202 vdd well_202 ntap1 A=4e-12 P=8e-6
XM10_60 net043 net050 vdd well_202 sg13_lv_pmos w=1u l=1u m=1
XT203 vdd well_203 ntap1 A=4e-12 P=8e-6
XM10_61 net043 net050 vdd well_203 sg13_lv_pmos w=1u l=1u m=1
XT204 vdd well_204 ntap1 A=4e-12 P=8e-6
XM10_62 net043 net050 vdd well_204 sg13_lv_pmos w=1u l=1u m=1
XT205 vdd well_205 ntap1 A=4e-12 P=8e-6
XM10_63 net043 net050 vdd well_205 sg13_lv_pmos w=1u l=1u m=1
XT206 vdd well_206 ntap1 A=4e-12 P=8e-6
XM10_64 net043 net050 vdd well_206 sg13_lv_pmos w=1u l=1u m=1
XT207 vdd well_207 ntap1 A=4e-12 P=8e-6
XM10_65 net043 net050 vdd well_207 sg13_lv_pmos w=1u l=1u m=1
XT208 vdd well_208 ntap1 A=4e-12 P=8e-6
XM10_66 net043 net050 vdd well_208 sg13_lv_pmos w=1u l=1u m=1
XT209 vdd well_209 ntap1 A=4e-12 P=8e-6
XM10_67 net043 net050 vdd well_209 sg13_lv_pmos w=1u l=1u m=1
XT210 vdd well_210 ntap1 A=4e-12 P=8e-6
XM10_68 net043 net050 vdd well_210 sg13_lv_pmos w=1u l=1u m=1
XT211 vdd well_211 ntap1 A=4e-12 P=8e-6
XM10_69 net043 net050 vdd well_211 sg13_lv_pmos w=1u l=1u m=1
XT212 vdd well_212 ntap1 A=4e-12 P=8e-6
XM10_70 net043 net050 vdd well_212 sg13_lv_pmos w=1u l=1u m=1
XT213 vdd well_213 ntap1 A=4e-12 P=8e-6
XM10_71 net043 net050 vdd well_213 sg13_lv_pmos w=1u l=1u m=1
XT214 vdd well_214 ntap1 A=4e-12 P=8e-6
XM10_72 net043 net050 vdd well_214 sg13_lv_pmos w=1u l=1u m=1
XT215 vdd well_215 ntap1 A=4e-12 P=8e-6
XM10_73 net043 net050 vdd well_215 sg13_lv_pmos w=1u l=1u m=1
XT216 vdd well_216 ntap1 A=4e-12 P=8e-6
XM10_74 net043 net050 vdd well_216 sg13_lv_pmos w=1u l=1u m=1
XT217 vdd well_217 ntap1 A=4e-12 P=8e-6
XM10_75 net043 net050 vdd well_217 sg13_lv_pmos w=1u l=1u m=1
XT218 vdd well_218 ntap1 A=4e-12 P=8e-6
XM10_76 net043 net050 vdd well_218 sg13_lv_pmos w=1u l=1u m=1
XT219 vdd well_219 ntap1 A=4e-12 P=8e-6
XM10_77 net043 net050 vdd well_219 sg13_lv_pmos w=1u l=1u m=1
XT220 vdd well_220 ntap1 A=4e-12 P=8e-6
XM10_78 net043 net050 vdd well_220 sg13_lv_pmos w=1u l=1u m=1
XT221 vdd well_221 ntap1 A=4e-12 P=8e-6
XM10_79 net043 net050 vdd well_221 sg13_lv_pmos w=1u l=1u m=1
XT222 vdd well_222 ntap1 A=4e-12 P=8e-6
XM10_80 net043 net050 vdd well_222 sg13_lv_pmos w=1u l=1u m=1
XT223 vdd well_223 ntap1 A=4e-12 P=8e-6
XM11_0 vout net050 vdd well_223 sg13_lv_pmos w=1u l=1u m=1
XT224 vdd well_224 ntap1 A=4e-12 P=8e-6
XM11_1 vout net050 vdd well_224 sg13_lv_pmos w=1u l=1u m=1
XT225 vdd well_225 ntap1 A=4e-12 P=8e-6
XM11_2 vout net050 vdd well_225 sg13_lv_pmos w=1u l=1u m=1
XT226 vdd well_226 ntap1 A=4e-12 P=8e-6
XM11_3 vout net050 vdd well_226 sg13_lv_pmos w=1u l=1u m=1
XT227 vdd well_227 ntap1 A=4e-12 P=8e-6
XM11_4 vout net050 vdd well_227 sg13_lv_pmos w=1u l=1u m=1
XT228 vdd well_228 ntap1 A=4e-12 P=8e-6
XM11_5 vout net050 vdd well_228 sg13_lv_pmos w=1u l=1u m=1
XT229 vdd well_229 ntap1 A=4e-12 P=8e-6
XM11_6 vout net050 vdd well_229 sg13_lv_pmos w=1u l=1u m=1
XT230 vdd well_230 ntap1 A=4e-12 P=8e-6
XM11_7 vout net050 vdd well_230 sg13_lv_pmos w=1u l=1u m=1
XT231 vdd well_231 ntap1 A=4e-12 P=8e-6
XM11_8 vout net050 vdd well_231 sg13_lv_pmos w=1u l=1u m=1
XT232 vdd well_232 ntap1 A=4e-12 P=8e-6
XM11_9 vout net050 vdd well_232 sg13_lv_pmos w=1u l=1u m=1
XT233 vdd well_233 ntap1 A=4e-12 P=8e-6
XM11_10 vout net050 vdd well_233 sg13_lv_pmos w=1u l=1u m=1
XT234 vdd well_234 ntap1 A=4e-12 P=8e-6
XM11_11 vout net050 vdd well_234 sg13_lv_pmos w=1u l=1u m=1
XT235 vdd well_235 ntap1 A=4e-12 P=8e-6
XM11_12 vout net050 vdd well_235 sg13_lv_pmos w=1u l=1u m=1
XT236 vdd well_236 ntap1 A=4e-12 P=8e-6
XM11_13 vout net050 vdd well_236 sg13_lv_pmos w=1u l=1u m=1
XT237 vdd well_237 ntap1 A=4e-12 P=8e-6
XM11_14 vout net050 vdd well_237 sg13_lv_pmos w=1u l=1u m=1
XT238 vdd well_238 ntap1 A=4e-12 P=8e-6
XM11_15 vout net050 vdd well_238 sg13_lv_pmos w=1u l=1u m=1
XT239 vdd well_239 ntap1 A=4e-12 P=8e-6
XM11_16 vout net050 vdd well_239 sg13_lv_pmos w=1u l=1u m=1
XT240 vdd well_240 ntap1 A=4e-12 P=8e-6
XM11_17 vout net050 vdd well_240 sg13_lv_pmos w=1u l=1u m=1
XT241 vdd well_241 ntap1 A=4e-12 P=8e-6
XM11_18 vout net050 vdd well_241 sg13_lv_pmos w=1u l=1u m=1
XT242 vdd well_242 ntap1 A=4e-12 P=8e-6
XM11_19 vout net050 vdd well_242 sg13_lv_pmos w=1u l=1u m=1
XT243 vdd well_243 ntap1 A=4e-12 P=8e-6
XM11_20 vout net050 vdd well_243 sg13_lv_pmos w=1u l=1u m=1
XT244 vdd well_244 ntap1 A=4e-12 P=8e-6
XM11_21 vout net050 vdd well_244 sg13_lv_pmos w=1u l=1u m=1
XT245 vdd well_245 ntap1 A=4e-12 P=8e-6
XM11_22 vout net050 vdd well_245 sg13_lv_pmos w=1u l=1u m=1
XT246 vdd well_246 ntap1 A=4e-12 P=8e-6
XM11_23 vout net050 vdd well_246 sg13_lv_pmos w=1u l=1u m=1
XT247 vdd well_247 ntap1 A=4e-12 P=8e-6
XM11_24 vout net050 vdd well_247 sg13_lv_pmos w=1u l=1u m=1
XT248 vdd well_248 ntap1 A=4e-12 P=8e-6
XM11_25 vout net050 vdd well_248 sg13_lv_pmos w=1u l=1u m=1
XT249 vdd well_249 ntap1 A=4e-12 P=8e-6
XM11_26 vout net050 vdd well_249 sg13_lv_pmos w=1u l=1u m=1
XT250 vdd well_250 ntap1 A=4e-12 P=8e-6
XM11_27 vout net050 vdd well_250 sg13_lv_pmos w=1u l=1u m=1
XT251 vdd well_251 ntap1 A=4e-12 P=8e-6
XM11_28 vout net050 vdd well_251 sg13_lv_pmos w=1u l=1u m=1
XT252 vdd well_252 ntap1 A=4e-12 P=8e-6
XM11_29 vout net050 vdd well_252 sg13_lv_pmos w=1u l=1u m=1
XT253 vdd well_253 ntap1 A=4e-12 P=8e-6
XM11_30 vout net050 vdd well_253 sg13_lv_pmos w=1u l=1u m=1
XT254 vdd well_254 ntap1 A=4e-12 P=8e-6
XM11_31 vout net050 vdd well_254 sg13_lv_pmos w=1u l=1u m=1
XT255 vdd well_255 ntap1 A=4e-12 P=8e-6
XM11_32 vout net050 vdd well_255 sg13_lv_pmos w=1u l=1u m=1
XT256 vdd well_256 ntap1 A=4e-12 P=8e-6
XM11_33 vout net050 vdd well_256 sg13_lv_pmos w=1u l=1u m=1
XT257 vdd well_257 ntap1 A=4e-12 P=8e-6
XM11_34 vout net050 vdd well_257 sg13_lv_pmos w=1u l=1u m=1
XT258 vdd well_258 ntap1 A=4e-12 P=8e-6
XM11_35 vout net050 vdd well_258 sg13_lv_pmos w=1u l=1u m=1
XT259 vdd well_259 ntap1 A=4e-12 P=8e-6
XM11_36 vout net050 vdd well_259 sg13_lv_pmos w=1u l=1u m=1
XT260 vdd well_260 ntap1 A=4e-12 P=8e-6
XM11_37 vout net050 vdd well_260 sg13_lv_pmos w=1u l=1u m=1
XT261 vdd well_261 ntap1 A=4e-12 P=8e-6
XM11_38 vout net050 vdd well_261 sg13_lv_pmos w=1u l=1u m=1
XT262 vdd well_262 ntap1 A=4e-12 P=8e-6
XM11_39 vout net050 vdd well_262 sg13_lv_pmos w=1u l=1u m=1
XT263 vdd well_263 ntap1 A=4e-12 P=8e-6
XM11_40 vout net050 vdd well_263 sg13_lv_pmos w=1u l=1u m=1
XT264 vdd well_264 ntap1 A=4e-12 P=8e-6
XM11_41 vout net050 vdd well_264 sg13_lv_pmos w=1u l=1u m=1
XT265 vdd well_265 ntap1 A=4e-12 P=8e-6
XM11_42 vout net050 vdd well_265 sg13_lv_pmos w=1u l=1u m=1
XT266 vdd well_266 ntap1 A=4e-12 P=8e-6
XM11_43 vout net050 vdd well_266 sg13_lv_pmos w=1u l=1u m=1
XT267 vdd well_267 ntap1 A=4e-12 P=8e-6
XM11_44 vout net050 vdd well_267 sg13_lv_pmos w=1u l=1u m=1
XT268 vdd well_268 ntap1 A=4e-12 P=8e-6
XM11_45 vout net050 vdd well_268 sg13_lv_pmos w=1u l=1u m=1
XT269 vdd well_269 ntap1 A=4e-12 P=8e-6
XM11_46 vout net050 vdd well_269 sg13_lv_pmos w=1u l=1u m=1
XT270 vdd well_270 ntap1 A=4e-12 P=8e-6
XM11_47 vout net050 vdd well_270 sg13_lv_pmos w=1u l=1u m=1
XT271 vdd well_271 ntap1 A=4e-12 P=8e-6
XM11_48 vout net050 vdd well_271 sg13_lv_pmos w=1u l=1u m=1
XT272 vdd well_272 ntap1 A=4e-12 P=8e-6
XM11_49 vout net050 vdd well_272 sg13_lv_pmos w=1u l=1u m=1
XT273 vdd well_273 ntap1 A=4e-12 P=8e-6
XM11_50 vout net050 vdd well_273 sg13_lv_pmos w=1u l=1u m=1
XT274 vdd well_274 ntap1 A=4e-12 P=8e-6
XM11_51 vout net050 vdd well_274 sg13_lv_pmos w=1u l=1u m=1
XT275 vdd well_275 ntap1 A=4e-12 P=8e-6
XM11_52 vout net050 vdd well_275 sg13_lv_pmos w=1u l=1u m=1
XT276 vdd well_276 ntap1 A=4e-12 P=8e-6
XM11_53 vout net050 vdd well_276 sg13_lv_pmos w=1u l=1u m=1
XT277 vdd well_277 ntap1 A=4e-12 P=8e-6
XM11_54 vout net050 vdd well_277 sg13_lv_pmos w=1u l=1u m=1
XT278 vdd well_278 ntap1 A=4e-12 P=8e-6
XM11_55 vout net050 vdd well_278 sg13_lv_pmos w=1u l=1u m=1
XT279 vdd well_279 ntap1 A=4e-12 P=8e-6
XM11_56 vout net050 vdd well_279 sg13_lv_pmos w=1u l=1u m=1
XT280 vdd well_280 ntap1 A=4e-12 P=8e-6
XM11_57 vout net050 vdd well_280 sg13_lv_pmos w=1u l=1u m=1
XT281 vdd well_281 ntap1 A=4e-12 P=8e-6
XM11_58 vout net050 vdd well_281 sg13_lv_pmos w=1u l=1u m=1
XT282 vdd well_282 ntap1 A=4e-12 P=8e-6
XM11_59 vout net050 vdd well_282 sg13_lv_pmos w=1u l=1u m=1
XT283 vdd well_283 ntap1 A=4e-12 P=8e-6
XM11_60 vout net050 vdd well_283 sg13_lv_pmos w=1u l=1u m=1
XT284 vdd well_284 ntap1 A=4e-12 P=8e-6
XM11_61 vout net050 vdd well_284 sg13_lv_pmos w=1u l=1u m=1
XT285 vdd well_285 ntap1 A=4e-12 P=8e-6
XM11_62 vout net050 vdd well_285 sg13_lv_pmos w=1u l=1u m=1
XT286 vdd well_286 ntap1 A=4e-12 P=8e-6
XM11_63 vout net050 vdd well_286 sg13_lv_pmos w=1u l=1u m=1
XT287 vdd well_287 ntap1 A=4e-12 P=8e-6
XM11_64 vout net050 vdd well_287 sg13_lv_pmos w=1u l=1u m=1
XT288 vdd well_288 ntap1 A=4e-12 P=8e-6
XM11_65 vout net050 vdd well_288 sg13_lv_pmos w=1u l=1u m=1
XT289 vdd well_289 ntap1 A=4e-12 P=8e-6
XM11_66 vout net050 vdd well_289 sg13_lv_pmos w=1u l=1u m=1
XT290 vdd well_290 ntap1 A=4e-12 P=8e-6
XM11_67 vout net050 vdd well_290 sg13_lv_pmos w=1u l=1u m=1
XT291 vdd well_291 ntap1 A=4e-12 P=8e-6
XM11_68 vout net050 vdd well_291 sg13_lv_pmos w=1u l=1u m=1
XT292 vdd well_292 ntap1 A=4e-12 P=8e-6
XM11_69 vout net050 vdd well_292 sg13_lv_pmos w=1u l=1u m=1
XT293 vdd well_293 ntap1 A=4e-12 P=8e-6
XM11_70 vout net050 vdd well_293 sg13_lv_pmos w=1u l=1u m=1
XT294 vdd well_294 ntap1 A=4e-12 P=8e-6
XM11_71 vout net050 vdd well_294 sg13_lv_pmos w=1u l=1u m=1
XT295 vdd well_295 ntap1 A=4e-12 P=8e-6
XM11_72 vout net050 vdd well_295 sg13_lv_pmos w=1u l=1u m=1
XT296 vdd well_296 ntap1 A=4e-12 P=8e-6
XM11_73 vout net050 vdd well_296 sg13_lv_pmos w=1u l=1u m=1
XT297 vdd well_297 ntap1 A=4e-12 P=8e-6
XM11_74 vout net050 vdd well_297 sg13_lv_pmos w=1u l=1u m=1
XT298 vdd well_298 ntap1 A=4e-12 P=8e-6
XM11_75 vout net050 vdd well_298 sg13_lv_pmos w=1u l=1u m=1
XT299 vdd well_299 ntap1 A=4e-12 P=8e-6
XM11_76 vout net050 vdd well_299 sg13_lv_pmos w=1u l=1u m=1
XT300 vdd well_300 ntap1 A=4e-12 P=8e-6
XM11_77 vout net050 vdd well_300 sg13_lv_pmos w=1u l=1u m=1
XT301 vdd well_301 ntap1 A=4e-12 P=8e-6
XM11_78 vout net050 vdd well_301 sg13_lv_pmos w=1u l=1u m=1
XT302 vdd well_302 ntap1 A=4e-12 P=8e-6
XM11_79 vout net050 vdd well_302 sg13_lv_pmos w=1u l=1u m=1
XT303 vdd well_303 ntap1 A=4e-12 P=8e-6
XM11_80 vout net050 vdd well_303 sg13_lv_pmos w=1u l=1u m=1
XT304 vdd well_304 ntap1 A=4e-12 P=8e-6
XM11_81 vout net050 vdd well_304 sg13_lv_pmos w=1u l=1u m=1
XT305 vdd well_305 ntap1 A=4e-12 P=8e-6
XM11_82 vout net050 vdd well_305 sg13_lv_pmos w=1u l=1u m=1
XT306 vdd well_306 ntap1 A=4e-12 P=8e-6
XM11_83 vout net050 vdd well_306 sg13_lv_pmos w=1u l=1u m=1
XT307 vdd well_307 ntap1 A=4e-12 P=8e-6
XM11_84 vout net050 vdd well_307 sg13_lv_pmos w=1u l=1u m=1
XT308 vdd well_308 ntap1 A=4e-12 P=8e-6
XM11_85 vout net050 vdd well_308 sg13_lv_pmos w=1u l=1u m=1
XT309 vdd well_309 ntap1 A=4e-12 P=8e-6
XM11_86 vout net050 vdd well_309 sg13_lv_pmos w=1u l=1u m=1
XT310 vdd well_310 ntap1 A=4e-12 P=8e-6
XM11_87 vout net050 vdd well_310 sg13_lv_pmos w=1u l=1u m=1
XT311 vdd well_311 ntap1 A=4e-12 P=8e-6
XM11_88 vout net050 vdd well_311 sg13_lv_pmos w=1u l=1u m=1
XT312 vdd well_312 ntap1 A=4e-12 P=8e-6
XM11_89 vout net050 vdd well_312 sg13_lv_pmos w=1u l=1u m=1
XT313 vdd well_313 ntap1 A=4e-12 P=8e-6
XM11_90 vout net050 vdd well_313 sg13_lv_pmos w=1u l=1u m=1
XT314 vdd well_314 ntap1 A=4e-12 P=8e-6
XM11_91 vout net050 vdd well_314 sg13_lv_pmos w=1u l=1u m=1
XT315 vdd well_315 ntap1 A=4e-12 P=8e-6
XM11_92 vout net050 vdd well_315 sg13_lv_pmos w=1u l=1u m=1
XT316 vdd well_316 ntap1 A=4e-12 P=8e-6
XM11_93 vout net050 vdd well_316 sg13_lv_pmos w=1u l=1u m=1
XT317 vdd well_317 ntap1 A=4e-12 P=8e-6
XM11_94 vout net050 vdd well_317 sg13_lv_pmos w=1u l=1u m=1
XT318 vdd well_318 ntap1 A=4e-12 P=8e-6
XM11_95 vout net050 vdd well_318 sg13_lv_pmos w=1u l=1u m=1
XT319 vdd well_319 ntap1 A=4e-12 P=8e-6
XM11_96 vout net050 vdd well_319 sg13_lv_pmos w=1u l=1u m=1
XT320 vdd well_320 ntap1 A=4e-12 P=8e-6
XM11_97 vout net050 vdd well_320 sg13_lv_pmos w=1u l=1u m=1
XT321 vdd well_321 ntap1 A=4e-12 P=8e-6
XM11_98 vout net050 vdd well_321 sg13_lv_pmos w=1u l=1u m=1
XT322 vdd well_322 ntap1 A=4e-12 P=8e-6
XM11_99 vout net050 vdd well_322 sg13_lv_pmos w=1u l=1u m=1
XT323 vdd well_323 ntap1 A=4e-12 P=8e-6
XM11_100 vout net050 vdd well_323 sg13_lv_pmos w=1u l=1u m=1
XT324 vdd well_324 ntap1 A=4e-12 P=8e-6
XM11_101 vout net050 vdd well_324 sg13_lv_pmos w=1u l=1u m=1
XT325 vdd well_325 ntap1 A=4e-12 P=8e-6
XM11_102 vout net050 vdd well_325 sg13_lv_pmos w=1u l=1u m=1
XT326 vdd well_326 ntap1 A=4e-12 P=8e-6
XM11_103 vout net050 vdd well_326 sg13_lv_pmos w=1u l=1u m=1
XT327 vdd well_327 ntap1 A=4e-12 P=8e-6
XM11_104 vout net050 vdd well_327 sg13_lv_pmos w=1u l=1u m=1
XT328 vdd well_328 ntap1 A=4e-12 P=8e-6
XM11_105 vout net050 vdd well_328 sg13_lv_pmos w=1u l=1u m=1
XT329 vdd well_329 ntap1 A=4e-12 P=8e-6
XM11_106 vout net050 vdd well_329 sg13_lv_pmos w=1u l=1u m=1
XT330 vdd well_330 ntap1 A=4e-12 P=8e-6
XM11_107 vout net050 vdd well_330 sg13_lv_pmos w=1u l=1u m=1
XT331 vdd well_331 ntap1 A=4e-12 P=8e-6
XM11_108 vout net050 vdd well_331 sg13_lv_pmos w=1u l=1u m=1
XT332 vdd well_332 ntap1 A=4e-12 P=8e-6
XM11_109 vout net050 vdd well_332 sg13_lv_pmos w=1u l=1u m=1
XT333 vdd well_333 ntap1 A=4e-12 P=8e-6
XM11_110 vout net050 vdd well_333 sg13_lv_pmos w=1u l=1u m=1
XT334 vdd well_334 ntap1 A=4e-12 P=8e-6
XM11_111 vout net050 vdd well_334 sg13_lv_pmos w=1u l=1u m=1
XT335 vdd well_335 ntap1 A=4e-12 P=8e-6
XM11_112 vout net050 vdd well_335 sg13_lv_pmos w=1u l=1u m=1
XT336 vdd well_336 ntap1 A=4e-12 P=8e-6
XM11_113 vout net050 vdd well_336 sg13_lv_pmos w=1u l=1u m=1
XT337 vdd well_337 ntap1 A=4e-12 P=8e-6
XM11_114 vout net050 vdd well_337 sg13_lv_pmos w=1u l=1u m=1
XT338 vdd well_338 ntap1 A=4e-12 P=8e-6
XM11_115 vout net050 vdd well_338 sg13_lv_pmos w=1u l=1u m=1
XT339 vdd well_339 ntap1 A=4e-12 P=8e-6
XM11_116 vout net050 vdd well_339 sg13_lv_pmos w=1u l=1u m=1
XT340 vdd well_340 ntap1 A=4e-12 P=8e-6
XM11_117 vout net050 vdd well_340 sg13_lv_pmos w=1u l=1u m=1
XT341 vdd well_341 ntap1 A=4e-12 P=8e-6
XM11_118 vout net050 vdd well_341 sg13_lv_pmos w=1u l=1u m=1
XT342 vdd well_342 ntap1 A=4e-12 P=8e-6
XM11_119 vout net050 vdd well_342 sg13_lv_pmos w=1u l=1u m=1
XT343 vdd well_343 ntap1 A=4e-12 P=8e-6
XM11_120 vout net050 vdd well_343 sg13_lv_pmos w=1u l=1u m=1
XT344 vdd well_344 ntap1 A=4e-12 P=8e-6
XM11_121 vout net050 vdd well_344 sg13_lv_pmos w=1u l=1u m=1
XT345 vdd well_345 ntap1 A=4e-12 P=8e-6
XM11_122 vout net050 vdd well_345 sg13_lv_pmos w=1u l=1u m=1
XT346 vdd well_346 ntap1 A=4e-12 P=8e-6
XM11_123 vout net050 vdd well_346 sg13_lv_pmos w=1u l=1u m=1
XT347 vdd well_347 ntap1 A=4e-12 P=8e-6
XM11_124 vout net050 vdd well_347 sg13_lv_pmos w=1u l=1u m=1
XT348 vdd well_348 ntap1 A=4e-12 P=8e-6
XM11_125 vout net050 vdd well_348 sg13_lv_pmos w=1u l=1u m=1
XT349 vdd well_349 ntap1 A=4e-12 P=8e-6
XM11_126 vout net050 vdd well_349 sg13_lv_pmos w=1u l=1u m=1
XT350 vdd well_350 ntap1 A=4e-12 P=8e-6
XM11_127 vout net050 vdd well_350 sg13_lv_pmos w=1u l=1u m=1
XT351 vdd well_351 ntap1 A=4e-12 P=8e-6
XM11_128 vout net050 vdd well_351 sg13_lv_pmos w=1u l=1u m=1
XT352 vdd well_352 ntap1 A=4e-12 P=8e-6
XM11_129 vout net050 vdd well_352 sg13_lv_pmos w=1u l=1u m=1
XT353 vdd well_353 ntap1 A=4e-12 P=8e-6
XM11_130 vout net050 vdd well_353 sg13_lv_pmos w=1u l=1u m=1
XT354 vdd well_354 ntap1 A=4e-12 P=8e-6
XM11_131 vout net050 vdd well_354 sg13_lv_pmos w=1u l=1u m=1
XT355 vdd well_355 ntap1 A=4e-12 P=8e-6
XM11_132 vout net050 vdd well_355 sg13_lv_pmos w=1u l=1u m=1
XT356 vdd well_356 ntap1 A=4e-12 P=8e-6
XM11_133 vout net050 vdd well_356 sg13_lv_pmos w=1u l=1u m=1
XT357 vdd well_357 ntap1 A=4e-12 P=8e-6
XM11_134 vout net050 vdd well_357 sg13_lv_pmos w=1u l=1u m=1
XT358 vdd well_358 ntap1 A=4e-12 P=8e-6
XM11_135 vout net050 vdd well_358 sg13_lv_pmos w=1u l=1u m=1
XT359 vdd well_359 ntap1 A=4e-12 P=8e-6
XM11_136 vout net050 vdd well_359 sg13_lv_pmos w=1u l=1u m=1
XT360 vdd well_360 ntap1 A=4e-12 P=8e-6
XM11_137 vout net050 vdd well_360 sg13_lv_pmos w=1u l=1u m=1
XT361 vdd well_361 ntap1 A=4e-12 P=8e-6
XM11_138 vout net050 vdd well_361 sg13_lv_pmos w=1u l=1u m=1
XT362 vdd well_362 ntap1 A=4e-12 P=8e-6
XM11_139 vout net050 vdd well_362 sg13_lv_pmos w=1u l=1u m=1
XT363 vdd well_363 ntap1 A=4e-12 P=8e-6
XM11_140 vout net050 vdd well_363 sg13_lv_pmos w=1u l=1u m=1
XT364 vdd well_364 ntap1 A=4e-12 P=8e-6
XM11_141 vout net050 vdd well_364 sg13_lv_pmos w=1u l=1u m=1
XT365 vdd well_365 ntap1 A=4e-12 P=8e-6
XM11_142 vout net050 vdd well_365 sg13_lv_pmos w=1u l=1u m=1
XT366 vdd well_366 ntap1 A=4e-12 P=8e-6
XM11_143 vout net050 vdd well_366 sg13_lv_pmos w=1u l=1u m=1
XT367 vdd well_367 ntap1 A=4e-12 P=8e-6
XM11_144 vout net050 vdd well_367 sg13_lv_pmos w=1u l=1u m=1
XT368 vdd well_368 ntap1 A=4e-12 P=8e-6
XM11_145 vout net050 vdd well_368 sg13_lv_pmos w=1u l=1u m=1
XT369 vdd well_369 ntap1 A=4e-12 P=8e-6
XM11_146 vout net050 vdd well_369 sg13_lv_pmos w=1u l=1u m=1
XT370 vdd well_370 ntap1 A=4e-12 P=8e-6
XM11_147 vout net050 vdd well_370 sg13_lv_pmos w=1u l=1u m=1
XT371 vdd well_371 ntap1 A=4e-12 P=8e-6
XM11_148 vout net050 vdd well_371 sg13_lv_pmos w=1u l=1u m=1
XT372 vdd well_372 ntap1 A=4e-12 P=8e-6
XM11_149 vout net050 vdd well_372 sg13_lv_pmos w=1u l=1u m=1
XT373 vdd well_373 ntap1 A=4e-12 P=8e-6
XM11_150 vout net050 vdd well_373 sg13_lv_pmos w=1u l=1u m=1
XT374 vdd well_374 ntap1 A=4e-12 P=8e-6
XM11_151 vout net050 vdd well_374 sg13_lv_pmos w=1u l=1u m=1
XT375 vdd well_375 ntap1 A=4e-12 P=8e-6
XM11_152 vout net050 vdd well_375 sg13_lv_pmos w=1u l=1u m=1
XT376 vdd well_376 ntap1 A=4e-12 P=8e-6
XM11_153 vout net050 vdd well_376 sg13_lv_pmos w=1u l=1u m=1
XT377 vdd well_377 ntap1 A=4e-12 P=8e-6
XM11_154 vout net050 vdd well_377 sg13_lv_pmos w=1u l=1u m=1
XT378 vdd well_378 ntap1 A=4e-12 P=8e-6
XM11_155 vout net050 vdd well_378 sg13_lv_pmos w=1u l=1u m=1
XT379 vdd well_379 ntap1 A=4e-12 P=8e-6
XM11_156 vout net050 vdd well_379 sg13_lv_pmos w=1u l=1u m=1
XT380 vdd well_380 ntap1 A=4e-12 P=8e-6
XM11_157 vout net050 vdd well_380 sg13_lv_pmos w=1u l=1u m=1
XT381 vdd well_381 ntap1 A=4e-12 P=8e-6
XM11_158 vout net050 vdd well_381 sg13_lv_pmos w=1u l=1u m=1
XT382 vdd well_382 ntap1 A=4e-12 P=8e-6
XM11_159 vout net050 vdd well_382 sg13_lv_pmos w=1u l=1u m=1
XT383 vdd well_383 ntap1 A=4e-12 P=8e-6
XM11_160 vout net050 vdd well_383 sg13_lv_pmos w=1u l=1u m=1
XT384 vdd well_384 ntap1 A=4e-12 P=8e-6
XM11_161 vout net050 vdd well_384 sg13_lv_pmos w=1u l=1u m=1
XT385 vdd well_385 ntap1 A=4e-12 P=8e-6
XM11_162 vout net050 vdd well_385 sg13_lv_pmos w=1u l=1u m=1
XT386 vdd well_386 ntap1 A=4e-12 P=8e-6
XM11_163 vout net050 vdd well_386 sg13_lv_pmos w=1u l=1u m=1
XT387 vdd well_387 ntap1 A=4e-12 P=8e-6
XM11_164 vout net050 vdd well_387 sg13_lv_pmos w=1u l=1u m=1
XT388 vdd well_388 ntap1 A=4e-12 P=8e-6
XM11_165 vout net050 vdd well_388 sg13_lv_pmos w=1u l=1u m=1
XT389 vdd well_389 ntap1 A=4e-12 P=8e-6
XM11_166 vout net050 vdd well_389 sg13_lv_pmos w=1u l=1u m=1
XT390 vdd well_390 ntap1 A=4e-12 P=8e-6
XM11_167 vout net050 vdd well_390 sg13_lv_pmos w=1u l=1u m=1
XT391 vdd well_391 ntap1 A=4e-12 P=8e-6
XM11_168 vout net050 vdd well_391 sg13_lv_pmos w=1u l=1u m=1
XT392 vdd well_392 ntap1 A=4e-12 P=8e-6
XM11_169 vout net050 vdd well_392 sg13_lv_pmos w=1u l=1u m=1
XT393 vdd well_393 ntap1 A=4e-12 P=8e-6
XM11_170 vout net050 vdd well_393 sg13_lv_pmos w=1u l=1u m=1
XT394 vdd well_394 ntap1 A=4e-12 P=8e-6
XM11_171 vout net050 vdd well_394 sg13_lv_pmos w=1u l=1u m=1
XT395 vdd well_395 ntap1 A=4e-12 P=8e-6
XM11_172 vout net050 vdd well_395 sg13_lv_pmos w=1u l=1u m=1
XT396 vdd well_396 ntap1 A=4e-12 P=8e-6
XM11_173 vout net050 vdd well_396 sg13_lv_pmos w=1u l=1u m=1
XT397 vdd well_397 ntap1 A=4e-12 P=8e-6
XM11_174 vout net050 vdd well_397 sg13_lv_pmos w=1u l=1u m=1
XT398 vdd well_398 ntap1 A=4e-12 P=8e-6
XM11_175 vout net050 vdd well_398 sg13_lv_pmos w=1u l=1u m=1
XT399 vdd well_399 ntap1 A=4e-12 P=8e-6
XM11_176 vout net050 vdd well_399 sg13_lv_pmos w=1u l=1u m=1
XT400 vdd well_400 ntap1 A=4e-12 P=8e-6
XM11_177 vout net050 vdd well_400 sg13_lv_pmos w=1u l=1u m=1
XT401 vdd well_401 ntap1 A=4e-12 P=8e-6
XM11_178 vout net050 vdd well_401 sg13_lv_pmos w=1u l=1u m=1
XT402 vdd well_402 ntap1 A=4e-12 P=8e-6
XM11_179 vout net050 vdd well_402 sg13_lv_pmos w=1u l=1u m=1
XT403 vdd well_403 ntap1 A=4e-12 P=8e-6
XM11_180 vout net050 vdd well_403 sg13_lv_pmos w=1u l=1u m=1
XT404 vdd well_404 ntap1 A=4e-12 P=8e-6
XM11_181 vout net050 vdd well_404 sg13_lv_pmos w=1u l=1u m=1
XT405 vdd well_405 ntap1 A=4e-12 P=8e-6
XM11_182 vout net050 vdd well_405 sg13_lv_pmos w=1u l=1u m=1
XT406 vdd well_406 ntap1 A=4e-12 P=8e-6
XM11_183 vout net050 vdd well_406 sg13_lv_pmos w=1u l=1u m=1
XT407 vdd well_407 ntap1 A=4e-12 P=8e-6
XM11_184 vout net050 vdd well_407 sg13_lv_pmos w=1u l=1u m=1
XT408 vdd well_408 ntap1 A=4e-12 P=8e-6
XM11_185 vout net050 vdd well_408 sg13_lv_pmos w=1u l=1u m=1
XT409 vdd well_409 ntap1 A=4e-12 P=8e-6
XM11_186 vout net050 vdd well_409 sg13_lv_pmos w=1u l=1u m=1
XT410 vdd well_410 ntap1 A=4e-12 P=8e-6
XM11_187 vout net050 vdd well_410 sg13_lv_pmos w=1u l=1u m=1
XT411 vdd well_411 ntap1 A=4e-12 P=8e-6
XM11_188 vout net050 vdd well_411 sg13_lv_pmos w=1u l=1u m=1
XT412 vdd well_412 ntap1 A=4e-12 P=8e-6
XM11_189 vout net050 vdd well_412 sg13_lv_pmos w=1u l=1u m=1
XT413 vdd well_413 ntap1 A=4e-12 P=8e-6
XM11_190 vout net050 vdd well_413 sg13_lv_pmos w=1u l=1u m=1
XT414 vdd well_414 ntap1 A=4e-12 P=8e-6
XM11_191 vout net050 vdd well_414 sg13_lv_pmos w=1u l=1u m=1
XT415 vdd well_415 ntap1 A=4e-12 P=8e-6
XM11_192 vout net050 vdd well_415 sg13_lv_pmos w=1u l=1u m=1
XT416 vdd well_416 ntap1 A=4e-12 P=8e-6
XM11_193 vout net050 vdd well_416 sg13_lv_pmos w=1u l=1u m=1
XT417 vdd well_417 ntap1 A=4e-12 P=8e-6
XM11_194 vout net050 vdd well_417 sg13_lv_pmos w=1u l=1u m=1
XT418 vdd well_418 ntap1 A=4e-12 P=8e-6
XM11_195 vout net050 vdd well_418 sg13_lv_pmos w=1u l=1u m=1
XT419 vdd well_419 ntap1 A=4e-12 P=8e-6
XM11_196 vout net050 vdd well_419 sg13_lv_pmos w=1u l=1u m=1
XT420 vdd well_420 ntap1 A=4e-12 P=8e-6
XM11_197 vout net050 vdd well_420 sg13_lv_pmos w=1u l=1u m=1
XT421 vdd well_421 ntap1 A=4e-12 P=8e-6
XM11_198 vout net050 vdd well_421 sg13_lv_pmos w=1u l=1u m=1
XT422 vdd well_422 ntap1 A=4e-12 P=8e-6
XM11_199 vout net050 vdd well_422 sg13_lv_pmos w=1u l=1u m=1
XT423 vdd well_423 ntap1 A=4e-12 P=8e-6
XM11_200 vout net050 vdd well_423 sg13_lv_pmos w=1u l=1u m=1
XT424 vdd well_424 ntap1 A=4e-12 P=8e-6
XM11_201 vout net050 vdd well_424 sg13_lv_pmos w=1u l=1u m=1
XT425 vdd well_425 ntap1 A=4e-12 P=8e-6
XM11_202 vout net050 vdd well_425 sg13_lv_pmos w=1u l=1u m=1
XT426 vdd well_426 ntap1 A=4e-12 P=8e-6
XM11_203 vout net050 vdd well_426 sg13_lv_pmos w=1u l=1u m=1
XT427 vdd well_427 ntap1 A=4e-12 P=8e-6
XM11_204 vout net050 vdd well_427 sg13_lv_pmos w=1u l=1u m=1
XT428 vdd well_428 ntap1 A=4e-12 P=8e-6
XM11_205 vout net050 vdd well_428 sg13_lv_pmos w=1u l=1u m=1
XT429 vdd well_429 ntap1 A=4e-12 P=8e-6
XM11_206 vout net050 vdd well_429 sg13_lv_pmos w=1u l=1u m=1
XT430 vdd well_430 ntap1 A=4e-12 P=8e-6
XM11_207 vout net050 vdd well_430 sg13_lv_pmos w=1u l=1u m=1
XT431 vdd well_431 ntap1 A=4e-12 P=8e-6
XM11_208 vout net050 vdd well_431 sg13_lv_pmos w=1u l=1u m=1
XT432 vdd well_432 ntap1 A=4e-12 P=8e-6
XM11_209 vout net050 vdd well_432 sg13_lv_pmos w=1u l=1u m=1
XT433 vdd well_433 ntap1 A=4e-12 P=8e-6
XM11_210 vout net050 vdd well_433 sg13_lv_pmos w=1u l=1u m=1
XT434 vdd well_434 ntap1 A=4e-12 P=8e-6
XM11_211 vout net050 vdd well_434 sg13_lv_pmos w=1u l=1u m=1
XT435 vdd well_435 ntap1 A=4e-12 P=8e-6
XM11_212 vout net050 vdd well_435 sg13_lv_pmos w=1u l=1u m=1
XT436 vdd well_436 ntap1 A=4e-12 P=8e-6
XM11_213 vout net050 vdd well_436 sg13_lv_pmos w=1u l=1u m=1
XT437 vdd well_437 ntap1 A=4e-12 P=8e-6
XM11_214 vout net050 vdd well_437 sg13_lv_pmos w=1u l=1u m=1
XT438 vdd well_438 ntap1 A=4e-12 P=8e-6
XM11_215 vout net050 vdd well_438 sg13_lv_pmos w=1u l=1u m=1
XT439 vdd well_439 ntap1 A=4e-12 P=8e-6
XM11_216 vout net050 vdd well_439 sg13_lv_pmos w=1u l=1u m=1
XT440 vdd well_440 ntap1 A=4e-12 P=8e-6
XM11_217 vout net050 vdd well_440 sg13_lv_pmos w=1u l=1u m=1
XT441 vdd well_441 ntap1 A=4e-12 P=8e-6
XM11_218 vout net050 vdd well_441 sg13_lv_pmos w=1u l=1u m=1
XT442 vdd well_442 ntap1 A=4e-12 P=8e-6
XM11_219 vout net050 vdd well_442 sg13_lv_pmos w=1u l=1u m=1
XT443 vdd well_443 ntap1 A=4e-12 P=8e-6
XM11_220 vout net050 vdd well_443 sg13_lv_pmos w=1u l=1u m=1
XT444 vdd well_444 ntap1 A=4e-12 P=8e-6
XM11_221 vout net050 vdd well_444 sg13_lv_pmos w=1u l=1u m=1
XT445 vdd well_445 ntap1 A=4e-12 P=8e-6
XM11_222 vout net050 vdd well_445 sg13_lv_pmos w=1u l=1u m=1
XT446 vdd well_446 ntap1 A=4e-12 P=8e-6
XM11_223 vout net050 vdd well_446 sg13_lv_pmos w=1u l=1u m=1
XT447 vdd well_447 ntap1 A=4e-12 P=8e-6
XM11_224 vout net050 vdd well_447 sg13_lv_pmos w=1u l=1u m=1
XT448 vdd well_448 ntap1 A=4e-12 P=8e-6
XM11_225 vout net050 vdd well_448 sg13_lv_pmos w=1u l=1u m=1
XT449 vdd well_449 ntap1 A=4e-12 P=8e-6
XM11_226 vout net050 vdd well_449 sg13_lv_pmos w=1u l=1u m=1
XT450 vdd well_450 ntap1 A=4e-12 P=8e-6
XM11_227 vout net050 vdd well_450 sg13_lv_pmos w=1u l=1u m=1
XT451 vdd well_451 ntap1 A=4e-12 P=8e-6
XM11_228 vout net050 vdd well_451 sg13_lv_pmos w=1u l=1u m=1
XT452 vdd well_452 ntap1 A=4e-12 P=8e-6
XM11_229 vout net050 vdd well_452 sg13_lv_pmos w=1u l=1u m=1
XT453 vdd well_453 ntap1 A=4e-12 P=8e-6
XM11_230 vout net050 vdd well_453 sg13_lv_pmos w=1u l=1u m=1
XT454 vdd well_454 ntap1 A=4e-12 P=8e-6
XM11_231 vout net050 vdd well_454 sg13_lv_pmos w=1u l=1u m=1
XT455 vdd well_455 ntap1 A=4e-12 P=8e-6
XM11_232 vout net050 vdd well_455 sg13_lv_pmos w=1u l=1u m=1
XT456 vdd well_456 ntap1 A=4e-12 P=8e-6
XM11_233 vout net050 vdd well_456 sg13_lv_pmos w=1u l=1u m=1
XT457 vdd well_457 ntap1 A=4e-12 P=8e-6
XM11_234 vout net050 vdd well_457 sg13_lv_pmos w=1u l=1u m=1
XT458 vdd well_458 ntap1 A=4e-12 P=8e-6
XM11_235 vout net050 vdd well_458 sg13_lv_pmos w=1u l=1u m=1
XT459 vdd well_459 ntap1 A=4e-12 P=8e-6
XM11_236 vout net050 vdd well_459 sg13_lv_pmos w=1u l=1u m=1
XT460 vdd well_460 ntap1 A=4e-12 P=8e-6
XM11_237 vout net050 vdd well_460 sg13_lv_pmos w=1u l=1u m=1
XT461 vdd well_461 ntap1 A=4e-12 P=8e-6
XM11_238 vout net050 vdd well_461 sg13_lv_pmos w=1u l=1u m=1
XT462 vdd well_462 ntap1 A=4e-12 P=8e-6
XM11_239 vout net050 vdd well_462 sg13_lv_pmos w=1u l=1u m=1
XT463 vdd well_463 ntap1 A=4e-12 P=8e-6
XM11_240 vout net050 vdd well_463 sg13_lv_pmos w=1u l=1u m=1
XT464 vdd well_464 ntap1 A=4e-12 P=8e-6
XM11_241 vout net050 vdd well_464 sg13_lv_pmos w=1u l=1u m=1
XT465 vdd well_465 ntap1 A=4e-12 P=8e-6
XM11_242 vout net050 vdd well_465 sg13_lv_pmos w=1u l=1u m=1
XT466 vdd well_466 ntap1 A=4e-12 P=8e-6
XM11_243 vout net050 vdd well_466 sg13_lv_pmos w=1u l=1u m=1
XT467 vdd well_467 ntap1 A=4e-12 P=8e-6
XM11_244 vout net050 vdd well_467 sg13_lv_pmos w=1u l=1u m=1
XT468 vdd well_468 ntap1 A=4e-12 P=8e-6
XM11_245 vout net050 vdd well_468 sg13_lv_pmos w=1u l=1u m=1
XT469 vdd well_469 ntap1 A=4e-12 P=8e-6
XM11_246 vout net050 vdd well_469 sg13_lv_pmos w=1u l=1u m=1
XT470 vdd well_470 ntap1 A=4e-12 P=8e-6
XM11_247 vout net050 vdd well_470 sg13_lv_pmos w=1u l=1u m=1
XT471 vdd well_471 ntap1 A=4e-12 P=8e-6
XM11_248 vout net050 vdd well_471 sg13_lv_pmos w=1u l=1u m=1
XT472 vdd well_472 ntap1 A=4e-12 P=8e-6
XM11_249 vout net050 vdd well_472 sg13_lv_pmos w=1u l=1u m=1
XT473 vdd well_473 ntap1 A=4e-12 P=8e-6
XM11_250 vout net050 vdd well_473 sg13_lv_pmos w=1u l=1u m=1
XT474 vdd well_474 ntap1 A=4e-12 P=8e-6
XM11_251 vout net050 vdd well_474 sg13_lv_pmos w=1u l=1u m=1
XT475 vdd well_475 ntap1 A=4e-12 P=8e-6
XM11_252 vout net050 vdd well_475 sg13_lv_pmos w=1u l=1u m=1
XT476 vdd well_476 ntap1 A=4e-12 P=8e-6
XM11_253 vout net050 vdd well_476 sg13_lv_pmos w=1u l=1u m=1
XT477 vdd well_477 ntap1 A=4e-12 P=8e-6
XM11_254 vout net050 vdd well_477 sg13_lv_pmos w=1u l=1u m=1
XT478 vdd well_478 ntap1 A=4e-12 P=8e-6
XM11_255 vout net050 vdd well_478 sg13_lv_pmos w=1u l=1u m=1
XT479 vdd well_479 ntap1 A=4e-12 P=8e-6
XM11_256 vout net050 vdd well_479 sg13_lv_pmos w=1u l=1u m=1
XT480 vdd well_480 ntap1 A=4e-12 P=8e-6
XM11_257 vout net050 vdd well_480 sg13_lv_pmos w=1u l=1u m=1
XT481 vdd well_481 ntap1 A=4e-12 P=8e-6
XM11_258 vout net050 vdd well_481 sg13_lv_pmos w=1u l=1u m=1
XT482 vdd well_482 ntap1 A=4e-12 P=8e-6
XM11_259 vout net050 vdd well_482 sg13_lv_pmos w=1u l=1u m=1
XT483 vdd well_483 ntap1 A=4e-12 P=8e-6
XM11_260 vout net050 vdd well_483 sg13_lv_pmos w=1u l=1u m=1
XT484 vdd well_484 ntap1 A=4e-12 P=8e-6
XM11_261 vout net050 vdd well_484 sg13_lv_pmos w=1u l=1u m=1
XT485 vdd well_485 ntap1 A=4e-12 P=8e-6
XM11_262 vout net050 vdd well_485 sg13_lv_pmos w=1u l=1u m=1
XT486 vdd well_486 ntap1 A=4e-12 P=8e-6
XM11_263 vout net050 vdd well_486 sg13_lv_pmos w=1u l=1u m=1
XT487 vdd well_487 ntap1 A=4e-12 P=8e-6
XM11_264 vout net050 vdd well_487 sg13_lv_pmos w=1u l=1u m=1
XT488 vdd well_488 ntap1 A=4e-12 P=8e-6
XM11_265 vout net050 vdd well_488 sg13_lv_pmos w=1u l=1u m=1
XT489 vdd well_489 ntap1 A=4e-12 P=8e-6
XM11_266 vout net050 vdd well_489 sg13_lv_pmos w=1u l=1u m=1
XT490 vdd well_490 ntap1 A=4e-12 P=8e-6
XM11_267 vout net050 vdd well_490 sg13_lv_pmos w=1u l=1u m=1
XT491 vdd well_491 ntap1 A=4e-12 P=8e-6
XM11_268 vout net050 vdd well_491 sg13_lv_pmos w=1u l=1u m=1
XT492 vdd well_492 ntap1 A=4e-12 P=8e-6
XM11_269 vout net050 vdd well_492 sg13_lv_pmos w=1u l=1u m=1
XT493 vdd well_493 ntap1 A=4e-12 P=8e-6
XM11_270 vout net050 vdd well_493 sg13_lv_pmos w=1u l=1u m=1
XT494 vdd well_494 ntap1 A=4e-12 P=8e-6
XM11_271 vout net050 vdd well_494 sg13_lv_pmos w=1u l=1u m=1
XT495 vdd well_495 ntap1 A=4e-12 P=8e-6
XM11_272 vout net050 vdd well_495 sg13_lv_pmos w=1u l=1u m=1
XT496 vdd well_496 ntap1 A=4e-12 P=8e-6
XM11_273 vout net050 vdd well_496 sg13_lv_pmos w=1u l=1u m=1
XT497 vdd well_497 ntap1 A=4e-12 P=8e-6
XM11_274 vout net050 vdd well_497 sg13_lv_pmos w=1u l=1u m=1
XT498 vdd well_498 ntap1 A=4e-12 P=8e-6
XM11_275 vout net050 vdd well_498 sg13_lv_pmos w=1u l=1u m=1
XT499 vdd well_499 ntap1 A=4e-12 P=8e-6
XM11_276 vout net050 vdd well_499 sg13_lv_pmos w=1u l=1u m=1
XT500 vdd well_500 ntap1 A=4e-12 P=8e-6
XM11_277 vout net050 vdd well_500 sg13_lv_pmos w=1u l=1u m=1
XT501 vdd well_501 ntap1 A=4e-12 P=8e-6
XM11_278 vout net050 vdd well_501 sg13_lv_pmos w=1u l=1u m=1
XT502 vdd well_502 ntap1 A=4e-12 P=8e-6
XM11_279 vout net050 vdd well_502 sg13_lv_pmos w=1u l=1u m=1
XT503 vdd well_503 ntap1 A=4e-12 P=8e-6
XM11_280 vout net050 vdd well_503 sg13_lv_pmos w=1u l=1u m=1
XT504 vdd well_504 ntap1 A=4e-12 P=8e-6
XM11_281 vout net050 vdd well_504 sg13_lv_pmos w=1u l=1u m=1
XT505 vdd well_505 ntap1 A=4e-12 P=8e-6
XM11_282 vout net050 vdd well_505 sg13_lv_pmos w=1u l=1u m=1
XT506 vdd well_506 ntap1 A=4e-12 P=8e-6
XM11_283 vout net050 vdd well_506 sg13_lv_pmos w=1u l=1u m=1
XT507 vdd well_507 ntap1 A=4e-12 P=8e-6
XM11_284 vout net050 vdd well_507 sg13_lv_pmos w=1u l=1u m=1
XT508 vdd well_508 ntap1 A=4e-12 P=8e-6
XM11_285 vout net050 vdd well_508 sg13_lv_pmos w=1u l=1u m=1
XT509 vdd well_509 ntap1 A=4e-12 P=8e-6
XM11_286 vout net050 vdd well_509 sg13_lv_pmos w=1u l=1u m=1
XT510 vdd well_510 ntap1 A=4e-12 P=8e-6
XM11_287 vout net050 vdd well_510 sg13_lv_pmos w=1u l=1u m=1
XT511 vdd well_511 ntap1 A=4e-12 P=8e-6
XM11_288 vout net050 vdd well_511 sg13_lv_pmos w=1u l=1u m=1
XT512 vdd well_512 ntap1 A=4e-12 P=8e-6
XM11_289 vout net050 vdd well_512 sg13_lv_pmos w=1u l=1u m=1
XT513 vdd well_513 ntap1 A=4e-12 P=8e-6
XM11_290 vout net050 vdd well_513 sg13_lv_pmos w=1u l=1u m=1
XT514 vdd well_514 ntap1 A=4e-12 P=8e-6
XM11_291 vout net050 vdd well_514 sg13_lv_pmos w=1u l=1u m=1
XT515 vdd well_515 ntap1 A=4e-12 P=8e-6
XM11_292 vout net050 vdd well_515 sg13_lv_pmos w=1u l=1u m=1
XT516 vdd well_516 ntap1 A=4e-12 P=8e-6
XM11_293 vout net050 vdd well_516 sg13_lv_pmos w=1u l=1u m=1
XT517 vdd well_517 ntap1 A=4e-12 P=8e-6
XM11_294 vout net050 vdd well_517 sg13_lv_pmos w=1u l=1u m=1
XT518 vdd well_518 ntap1 A=4e-12 P=8e-6
XM11_295 vout net050 vdd well_518 sg13_lv_pmos w=1u l=1u m=1
XT519 vdd well_519 ntap1 A=4e-12 P=8e-6
XM11_296 vout net050 vdd well_519 sg13_lv_pmos w=1u l=1u m=1
XT520 vdd well_520 ntap1 A=4e-12 P=8e-6
XM11_297 vout net050 vdd well_520 sg13_lv_pmos w=1u l=1u m=1
XT521 vdd well_521 ntap1 A=4e-12 P=8e-6
XM11_298 vout net050 vdd well_521 sg13_lv_pmos w=1u l=1u m=1
XT522 vdd well_522 ntap1 A=4e-12 P=8e-6
XM11_299 vout net050 vdd well_522 sg13_lv_pmos w=1u l=1u m=1
XT523 vdd well_523 ntap1 A=4e-12 P=8e-6
XM11_300 vout net050 vdd well_523 sg13_lv_pmos w=1u l=1u m=1
XT524 vdd well_524 ntap1 A=4e-12 P=8e-6
XM11_301 vout net050 vdd well_524 sg13_lv_pmos w=1u l=1u m=1
XT525 vdd well_525 ntap1 A=4e-12 P=8e-6
XM11_302 vout net050 vdd well_525 sg13_lv_pmos w=1u l=1u m=1
XT526 vdd well_526 ntap1 A=4e-12 P=8e-6
XM11_303 vout net050 vdd well_526 sg13_lv_pmos w=1u l=1u m=1
XT527 vdd well_527 ntap1 A=4e-12 P=8e-6
XM11_304 vout net050 vdd well_527 sg13_lv_pmos w=1u l=1u m=1
XT528 vdd well_528 ntap1 A=4e-12 P=8e-6
XM11_305 vout net050 vdd well_528 sg13_lv_pmos w=1u l=1u m=1
XT529 vdd well_529 ntap1 A=4e-12 P=8e-6
XM11_306 vout net050 vdd well_529 sg13_lv_pmos w=1u l=1u m=1
XT530 vdd well_530 ntap1 A=4e-12 P=8e-6
XM11_307 vout net050 vdd well_530 sg13_lv_pmos w=1u l=1u m=1
XT531 vdd well_531 ntap1 A=4e-12 P=8e-6
XM11_308 vout net050 vdd well_531 sg13_lv_pmos w=1u l=1u m=1
XT532 vdd well_532 ntap1 A=4e-12 P=8e-6
XM11_309 vout net050 vdd well_532 sg13_lv_pmos w=1u l=1u m=1
XT533 vdd well_533 ntap1 A=4e-12 P=8e-6
XM11_310 vout net050 vdd well_533 sg13_lv_pmos w=1u l=1u m=1
XT534 vdd well_534 ntap1 A=4e-12 P=8e-6
XM11_311 vout net050 vdd well_534 sg13_lv_pmos w=1u l=1u m=1
XT535 vdd well_535 ntap1 A=4e-12 P=8e-6
XM11_312 vout net050 vdd well_535 sg13_lv_pmos w=1u l=1u m=1
XT536 vdd well_536 ntap1 A=4e-12 P=8e-6
XM11_313 vout net050 vdd well_536 sg13_lv_pmos w=1u l=1u m=1
XT537 vdd well_537 ntap1 A=4e-12 P=8e-6
XM11_314 vout net050 vdd well_537 sg13_lv_pmos w=1u l=1u m=1
XT538 vdd well_538 ntap1 A=4e-12 P=8e-6
XM11_315 vout net050 vdd well_538 sg13_lv_pmos w=1u l=1u m=1
XT539 vdd well_539 ntap1 A=4e-12 P=8e-6
XM11_316 vout net050 vdd well_539 sg13_lv_pmos w=1u l=1u m=1
XT540 vdd well_540 ntap1 A=4e-12 P=8e-6
XM11_317 vout net050 vdd well_540 sg13_lv_pmos w=1u l=1u m=1
XT541 vdd well_541 ntap1 A=4e-12 P=8e-6
XM11_318 vout net050 vdd well_541 sg13_lv_pmos w=1u l=1u m=1
XT542 vdd well_542 ntap1 A=4e-12 P=8e-6
XM11_319 vout net050 vdd well_542 sg13_lv_pmos w=1u l=1u m=1
XT543 vdd well_543 ntap1 A=4e-12 P=8e-6
XM11_320 vout net050 vdd well_543 sg13_lv_pmos w=1u l=1u m=1
XT544 vdd well_544 ntap1 A=4e-12 P=8e-6
XM11_321 vout net050 vdd well_544 sg13_lv_pmos w=1u l=1u m=1
XT545 vdd well_545 ntap1 A=4e-12 P=8e-6
XM11_322 vout net050 vdd well_545 sg13_lv_pmos w=1u l=1u m=1
XT546 vdd well_546 ntap1 A=4e-12 P=8e-6
XM11_323 vout net050 vdd well_546 sg13_lv_pmos w=1u l=1u m=1
XT547 vdd well_547 ntap1 A=4e-12 P=8e-6
XM11_324 vout net050 vdd well_547 sg13_lv_pmos w=1u l=1u m=1
XT548 vdd well_548 ntap1 A=4e-12 P=8e-6
XM11_325 vout net050 vdd well_548 sg13_lv_pmos w=1u l=1u m=1
XT549 vdd well_549 ntap1 A=4e-12 P=8e-6
XM11_326 vout net050 vdd well_549 sg13_lv_pmos w=1u l=1u m=1
XT550 vdd well_550 ntap1 A=4e-12 P=8e-6
XM11_327 vout net050 vdd well_550 sg13_lv_pmos w=1u l=1u m=1
XT551 vdd well_551 ntap1 A=4e-12 P=8e-6
XM11_328 vout net050 vdd well_551 sg13_lv_pmos w=1u l=1u m=1
XT552 vdd well_552 ntap1 A=4e-12 P=8e-6
XM11_329 vout net050 vdd well_552 sg13_lv_pmos w=1u l=1u m=1
XT553 vdd well_553 ntap1 A=4e-12 P=8e-6
XM11_330 vout net050 vdd well_553 sg13_lv_pmos w=1u l=1u m=1
XT554 vdd well_554 ntap1 A=4e-12 P=8e-6
XM11_331 vout net050 vdd well_554 sg13_lv_pmos w=1u l=1u m=1
XT555 vdd well_555 ntap1 A=4e-12 P=8e-6
XM11_332 vout net050 vdd well_555 sg13_lv_pmos w=1u l=1u m=1
XT556 vdd well_556 ntap1 A=4e-12 P=8e-6
XM11_333 vout net050 vdd well_556 sg13_lv_pmos w=1u l=1u m=1
XT557 vdd well_557 ntap1 A=4e-12 P=8e-6
XM11_334 vout net050 vdd well_557 sg13_lv_pmos w=1u l=1u m=1
XT558 vdd well_558 ntap1 A=4e-12 P=8e-6
XM11_335 vout net050 vdd well_558 sg13_lv_pmos w=1u l=1u m=1
XT559 vdd well_559 ntap1 A=4e-12 P=8e-6
XM11_336 vout net050 vdd well_559 sg13_lv_pmos w=1u l=1u m=1
XT560 vdd well_560 ntap1 A=4e-12 P=8e-6
XM11_337 vout net050 vdd well_560 sg13_lv_pmos w=1u l=1u m=1
XT561 vdd well_561 ntap1 A=4e-12 P=8e-6
XM11_338 vout net050 vdd well_561 sg13_lv_pmos w=1u l=1u m=1
XT562 vdd well_562 ntap1 A=4e-12 P=8e-6
XM11_339 vout net050 vdd well_562 sg13_lv_pmos w=1u l=1u m=1
XT563 vdd well_563 ntap1 A=4e-12 P=8e-6
XM11_340 vout net050 vdd well_563 sg13_lv_pmos w=1u l=1u m=1
XT564 vdd well_564 ntap1 A=4e-12 P=8e-6
XM11_341 vout net050 vdd well_564 sg13_lv_pmos w=1u l=1u m=1
XT565 vdd well_565 ntap1 A=4e-12 P=8e-6
XM11_342 vout net050 vdd well_565 sg13_lv_pmos w=1u l=1u m=1
XT566 vdd well_566 ntap1 A=4e-12 P=8e-6
XM11_343 vout net050 vdd well_566 sg13_lv_pmos w=1u l=1u m=1
XT567 vdd well_567 ntap1 A=4e-12 P=8e-6
XM11_344 vout net050 vdd well_567 sg13_lv_pmos w=1u l=1u m=1
XT568 vdd well_568 ntap1 A=4e-12 P=8e-6
XM11_345 vout net050 vdd well_568 sg13_lv_pmos w=1u l=1u m=1
XT569 vdd well_569 ntap1 A=4e-12 P=8e-6
XM11_346 vout net050 vdd well_569 sg13_lv_pmos w=1u l=1u m=1
XT570 vdd well_570 ntap1 A=4e-12 P=8e-6
XM11_347 vout net050 vdd well_570 sg13_lv_pmos w=1u l=1u m=1
XT571 vdd well_571 ntap1 A=4e-12 P=8e-6
XM11_348 vout net050 vdd well_571 sg13_lv_pmos w=1u l=1u m=1
XT572 vdd well_572 ntap1 A=4e-12 P=8e-6
XM11_349 vout net050 vdd well_572 sg13_lv_pmos w=1u l=1u m=1
XT573 vdd well_573 ntap1 A=4e-12 P=8e-6
XM11_350 vout net050 vdd well_573 sg13_lv_pmos w=1u l=1u m=1
XT574 vdd well_574 ntap1 A=4e-12 P=8e-6
XM11_351 vout net050 vdd well_574 sg13_lv_pmos w=1u l=1u m=1
XT575 vdd well_575 ntap1 A=4e-12 P=8e-6
XM11_352 vout net050 vdd well_575 sg13_lv_pmos w=1u l=1u m=1
XT576 vdd well_576 ntap1 A=4e-12 P=8e-6
XM11_353 vout net050 vdd well_576 sg13_lv_pmos w=1u l=1u m=1
XT577 vdd well_577 ntap1 A=4e-12 P=8e-6
XM11_354 vout net050 vdd well_577 sg13_lv_pmos w=1u l=1u m=1
XT578 vdd well_578 ntap1 A=4e-12 P=8e-6
XM11_355 vout net050 vdd well_578 sg13_lv_pmos w=1u l=1u m=1
XT579 vdd well_579 ntap1 A=4e-12 P=8e-6
XM11_356 vout net050 vdd well_579 sg13_lv_pmos w=1u l=1u m=1
XT580 vdd well_580 ntap1 A=4e-12 P=8e-6
XM11_357 vout net050 vdd well_580 sg13_lv_pmos w=1u l=1u m=1
XT581 vdd well_581 ntap1 A=4e-12 P=8e-6
XM11_358 vout net050 vdd well_581 sg13_lv_pmos w=1u l=1u m=1
XT582 vdd well_582 ntap1 A=4e-12 P=8e-6
XM11_359 vout net050 vdd well_582 sg13_lv_pmos w=1u l=1u m=1
XT583 vdd well_583 ntap1 A=4e-12 P=8e-6
XM11_360 vout net050 vdd well_583 sg13_lv_pmos w=1u l=1u m=1
XT584 vdd well_584 ntap1 A=4e-12 P=8e-6
XM11_361 vout net050 vdd well_584 sg13_lv_pmos w=1u l=1u m=1
XT585 vdd well_585 ntap1 A=4e-12 P=8e-6
XM11_362 vout net050 vdd well_585 sg13_lv_pmos w=1u l=1u m=1
XT586 vdd well_586 ntap1 A=4e-12 P=8e-6
XM11_363 vout net050 vdd well_586 sg13_lv_pmos w=1u l=1u m=1
XT587 vdd well_587 ntap1 A=4e-12 P=8e-6
XM11_364 vout net050 vdd well_587 sg13_lv_pmos w=1u l=1u m=1
XT588 vdd well_588 ntap1 A=4e-12 P=8e-6
XM11_365 vout net050 vdd well_588 sg13_lv_pmos w=1u l=1u m=1
XT589 vdd well_589 ntap1 A=4e-12 P=8e-6
XM11_366 vout net050 vdd well_589 sg13_lv_pmos w=1u l=1u m=1
XT590 vdd well_590 ntap1 A=4e-12 P=8e-6
XM11_367 vout net050 vdd well_590 sg13_lv_pmos w=1u l=1u m=1
XT591 vdd well_591 ntap1 A=4e-12 P=8e-6
XM11_368 vout net050 vdd well_591 sg13_lv_pmos w=1u l=1u m=1
XT592 vdd well_592 ntap1 A=4e-12 P=8e-6
XM11_369 vout net050 vdd well_592 sg13_lv_pmos w=1u l=1u m=1
XT593 vdd well_593 ntap1 A=4e-12 P=8e-6
XM11_370 vout net050 vdd well_593 sg13_lv_pmos w=1u l=1u m=1
XT594 vdd well_594 ntap1 A=4e-12 P=8e-6
XM11_371 vout net050 vdd well_594 sg13_lv_pmos w=1u l=1u m=1
XT595 vdd well_595 ntap1 A=4e-12 P=8e-6
XM11_372 vout net050 vdd well_595 sg13_lv_pmos w=1u l=1u m=1
XT596 vdd well_596 ntap1 A=4e-12 P=8e-6
XM11_373 vout net050 vdd well_596 sg13_lv_pmos w=1u l=1u m=1
XT597 vdd well_597 ntap1 A=4e-12 P=8e-6
XM11_374 vout net050 vdd well_597 sg13_lv_pmos w=1u l=1u m=1
XT598 vdd well_598 ntap1 A=4e-12 P=8e-6
XM11_375 vout net050 vdd well_598 sg13_lv_pmos w=1u l=1u m=1
XT599 vdd well_599 ntap1 A=4e-12 P=8e-6
XM11_376 vout net050 vdd well_599 sg13_lv_pmos w=1u l=1u m=1
XT600 vdd well_600 ntap1 A=4e-12 P=8e-6
XM11_377 vout net050 vdd well_600 sg13_lv_pmos w=1u l=1u m=1
XT601 vdd well_601 ntap1 A=4e-12 P=8e-6
XM11_378 vout net050 vdd well_601 sg13_lv_pmos w=1u l=1u m=1
XT602 vdd well_602 ntap1 A=4e-12 P=8e-6
XM11_379 vout net050 vdd well_602 sg13_lv_pmos w=1u l=1u m=1
XT603 vdd well_603 ntap1 A=4e-12 P=8e-6
XM11_380 vout net050 vdd well_603 sg13_lv_pmos w=1u l=1u m=1
XT604 vdd well_604 ntap1 A=4e-12 P=8e-6
XM11_381 vout net050 vdd well_604 sg13_lv_pmos w=1u l=1u m=1
XT605 vdd well_605 ntap1 A=4e-12 P=8e-6
XM11_382 vout net050 vdd well_605 sg13_lv_pmos w=1u l=1u m=1
XT606 vdd well_606 ntap1 A=4e-12 P=8e-6
XM11_383 vout net050 vdd well_606 sg13_lv_pmos w=1u l=1u m=1
XT607 vdd well_607 ntap1 A=4e-12 P=8e-6
XM11_384 vout net050 vdd well_607 sg13_lv_pmos w=1u l=1u m=1
XT608 vdd well_608 ntap1 A=4e-12 P=8e-6
XM11_385 vout net050 vdd well_608 sg13_lv_pmos w=1u l=1u m=1
XT609 vdd well_609 ntap1 A=4e-12 P=8e-6
XM11_386 vout net050 vdd well_609 sg13_lv_pmos w=1u l=1u m=1
XT610 vdd well_610 ntap1 A=4e-12 P=8e-6
XM11_387 vout net050 vdd well_610 sg13_lv_pmos w=1u l=1u m=1
XT611 vdd well_611 ntap1 A=4e-12 P=8e-6
XM11_388 vout net050 vdd well_611 sg13_lv_pmos w=1u l=1u m=1
XT612 vdd well_612 ntap1 A=4e-12 P=8e-6
XM11_389 vout net050 vdd well_612 sg13_lv_pmos w=1u l=1u m=1
XT613 vdd well_613 ntap1 A=4e-12 P=8e-6
XM11_390 vout net050 vdd well_613 sg13_lv_pmos w=1u l=1u m=1
XT614 vdd well_614 ntap1 A=4e-12 P=8e-6
XM11_391 vout net050 vdd well_614 sg13_lv_pmos w=1u l=1u m=1
XT615 vdd well_615 ntap1 A=4e-12 P=8e-6
XM11_392 vout net050 vdd well_615 sg13_lv_pmos w=1u l=1u m=1
XT616 vdd well_616 ntap1 A=4e-12 P=8e-6
XM11_393 vout net050 vdd well_616 sg13_lv_pmos w=1u l=1u m=1
XT617 vdd well_617 ntap1 A=4e-12 P=8e-6
XM11_394 vout net050 vdd well_617 sg13_lv_pmos w=1u l=1u m=1
XT618 vdd well_618 ntap1 A=4e-12 P=8e-6
XM11_395 vout net050 vdd well_618 sg13_lv_pmos w=1u l=1u m=1
XT619 vdd well_619 ntap1 A=4e-12 P=8e-6
XM11_396 vout net050 vdd well_619 sg13_lv_pmos w=1u l=1u m=1
XT620 vdd well_620 ntap1 A=4e-12 P=8e-6
XM11_397 vout net050 vdd well_620 sg13_lv_pmos w=1u l=1u m=1
XT621 vdd well_621 ntap1 A=4e-12 P=8e-6
XM11_398 vout net050 vdd well_621 sg13_lv_pmos w=1u l=1u m=1
XT622 vdd well_622 ntap1 A=4e-12 P=8e-6
XM11_399 vout net050 vdd well_622 sg13_lv_pmos w=1u l=1u m=1
XT623 vss sub ptap1 A=4e-12 P=8e-6
XM12_0 vb4 vb3 net54 sub sg13_lv_nmos w=1u l=1u m=1
XT624 vss sub ptap1 A=4e-12 P=8e-6
XM12_1 vb4 vb3 net54 sub sg13_lv_nmos w=1u l=1u m=1
XT625 vss sub ptap1 A=4e-12 P=8e-6
XM12_2 vb4 vb3 net54 sub sg13_lv_nmos w=1u l=1u m=1
XT626 vss sub ptap1 A=4e-12 P=8e-6
XM12_3 vb4 vb3 net54 sub sg13_lv_nmos w=1u l=1u m=1
XT627 vss sub ptap1 A=4e-12 P=8e-6
XM12_4 vb4 vb3 net54 sub sg13_lv_nmos w=1u l=1u m=1
XT628 vss sub ptap1 A=4e-12 P=8e-6
XM12_5 vb4 vb3 net54 sub sg13_lv_nmos w=1u l=1u m=1
XT629 vss sub ptap1 A=4e-12 P=8e-6
XM12_6 vb4 vb3 net54 sub sg13_lv_nmos w=1u l=1u m=1
XT630 vss sub ptap1 A=4e-12 P=8e-6
XM12_7 vb4 vb3 net54 sub sg13_lv_nmos w=1u l=1u m=1
XT631 vss sub ptap1 A=4e-12 P=8e-6
XM12_8 vb4 vb3 net54 sub sg13_lv_nmos w=1u l=1u m=1
XT632 vss sub ptap1 A=4e-12 P=8e-6
XM12_9 vb4 vb3 net54 sub sg13_lv_nmos w=1u l=1u m=1
XT633 vss sub ptap1 A=4e-12 P=8e-6
XM12_10 vb4 vb3 net54 sub sg13_lv_nmos w=1u l=1u m=1
XT634 vss sub ptap1 A=4e-12 P=8e-6
XM12_11 vb4 vb3 net54 sub sg13_lv_nmos w=1u l=1u m=1
XT635 vss sub ptap1 A=4e-12 P=8e-6
XM12_12 vb4 vb3 net54 sub sg13_lv_nmos w=1u l=1u m=1
XT636 vss sub ptap1 A=4e-12 P=8e-6
XM12_13 vb4 vb3 net54 sub sg13_lv_nmos w=1u l=1u m=1
XT637 vss sub ptap1 A=4e-12 P=8e-6
XM12_14 vb4 vb3 net54 sub sg13_lv_nmos w=1u l=1u m=1
XT638 vss sub ptap1 A=4e-12 P=8e-6
XM12_15 vb4 vb3 net54 sub sg13_lv_nmos w=1u l=1u m=1
XT639 vss sub ptap1 A=4e-12 P=8e-6
XM12_16 vb4 vb3 net54 sub sg13_lv_nmos w=1u l=1u m=1
XT640 vss sub ptap1 A=4e-12 P=8e-6
XM12_17 vb4 vb3 net54 sub sg13_lv_nmos w=1u l=1u m=1
XT641 vss sub ptap1 A=4e-12 P=8e-6
XM12_18 vb4 vb3 net54 sub sg13_lv_nmos w=1u l=1u m=1
XT642 vss sub ptap1 A=4e-12 P=8e-6
XM12_19 vb4 vb3 net54 sub sg13_lv_nmos w=1u l=1u m=1
XT643 vss sub ptap1 A=4e-12 P=8e-6
XM12_20 vb4 vb3 net54 sub sg13_lv_nmos w=1u l=1u m=1
XT644 vss sub ptap1 A=4e-12 P=8e-6
XM12_21 vb4 vb3 net54 sub sg13_lv_nmos w=1u l=1u m=1
XT645 vss sub ptap1 A=4e-12 P=8e-6
XM12_22 vb4 vb3 net54 sub sg13_lv_nmos w=1u l=1u m=1
XT646 vss sub ptap1 A=4e-12 P=8e-6
XM12_23 vb4 vb3 net54 sub sg13_lv_nmos w=1u l=1u m=1
XT647 vss sub ptap1 A=4e-12 P=8e-6
XM12_24 vb4 vb3 net54 sub sg13_lv_nmos w=1u l=1u m=1
XT648 vss sub ptap1 A=4e-12 P=8e-6
XM12_25 vb4 vb3 net54 sub sg13_lv_nmos w=1u l=1u m=1
XT649 vss sub ptap1 A=4e-12 P=8e-6
XM12_26 vb4 vb3 net54 sub sg13_lv_nmos w=1u l=1u m=1
XT650 vss sub ptap1 A=4e-12 P=8e-6
XM12_27 vb4 vb3 net54 sub sg13_lv_nmos w=1u l=1u m=1
XT651 vss sub ptap1 A=4e-12 P=8e-6
XM12_28 vb4 vb3 net54 sub sg13_lv_nmos w=1u l=1u m=1
XT652 vss sub ptap1 A=4e-12 P=8e-6
XM12_29 vb4 vb3 net54 sub sg13_lv_nmos w=1u l=1u m=1
XT653 vss sub ptap1 A=4e-12 P=8e-6
XM12_30 vb4 vb3 net54 sub sg13_lv_nmos w=1u l=1u m=1
XT654 vss sub ptap1 A=4e-12 P=8e-6
XM12_31 vb4 vb3 net54 sub sg13_lv_nmos w=1u l=1u m=1
XT655 vss sub ptap1 A=4e-12 P=8e-6
XM12_32 vb4 vb3 net54 sub sg13_lv_nmos w=1u l=1u m=1
XT656 vss sub ptap1 A=4e-12 P=8e-6
XM12_33 vb4 vb3 net54 sub sg13_lv_nmos w=1u l=1u m=1
XT657 vss sub ptap1 A=4e-12 P=8e-6
XM12_34 vb4 vb3 net54 sub sg13_lv_nmos w=1u l=1u m=1
XT658 vss sub ptap1 A=4e-12 P=8e-6
XM12_35 vb4 vb3 net54 sub sg13_lv_nmos w=1u l=1u m=1
XT659 vss sub ptap1 A=4e-12 P=8e-6
XM12_36 vb4 vb3 net54 sub sg13_lv_nmos w=1u l=1u m=1
XT660 vss sub ptap1 A=4e-12 P=8e-6
XM12_37 vb4 vb3 net54 sub sg13_lv_nmos w=1u l=1u m=1
XT661 vss sub ptap1 A=4e-12 P=8e-6
XM12_38 vb4 vb3 net54 sub sg13_lv_nmos w=1u l=1u m=1
XT662 vss sub ptap1 A=4e-12 P=8e-6
XM12_39 vb4 vb3 net54 sub sg13_lv_nmos w=1u l=1u m=1
XT663 vss sub ptap1 A=4e-12 P=8e-6
XM12_40 vb4 vb3 net54 sub sg13_lv_nmos w=1u l=1u m=1
XT664 vss sub ptap1 A=4e-12 P=8e-6
XM12_41 vb4 vb3 net54 sub sg13_lv_nmos w=1u l=1u m=1
XT665 vss sub ptap1 A=4e-12 P=8e-6
XM12_42 vb4 vb3 net54 sub sg13_lv_nmos w=1u l=1u m=1
XT666 vss sub ptap1 A=4e-12 P=8e-6
XM12_43 vb4 vb3 net54 sub sg13_lv_nmos w=1u l=1u m=1
XT667 vss sub ptap1 A=4e-12 P=8e-6
XM12_44 vb4 vb3 net54 sub sg13_lv_nmos w=1u l=1u m=1
XT668 vss sub ptap1 A=4e-12 P=8e-6
XM12_45 vb4 vb3 net54 sub sg13_lv_nmos w=1u l=1u m=1
XT669 vss sub ptap1 A=4e-12 P=8e-6
XM12_46 vb4 vb3 net54 sub sg13_lv_nmos w=1u l=1u m=1
XT670 vss sub ptap1 A=4e-12 P=8e-6
XM12_47 vb4 vb3 net54 sub sg13_lv_nmos w=1u l=1u m=1
XT671 vss sub ptap1 A=4e-12 P=8e-6
XM12_48 vb4 vb3 net54 sub sg13_lv_nmos w=1u l=1u m=1
XT672 vss sub ptap1 A=4e-12 P=8e-6
XM12_49 vb4 vb3 net54 sub sg13_lv_nmos w=1u l=1u m=1
XT673 vss sub ptap1 A=4e-12 P=8e-6
XM12_50 vb4 vb3 net54 sub sg13_lv_nmos w=1u l=1u m=1
XT674 vss sub ptap1 A=4e-12 P=8e-6
XM12_51 vb4 vb3 net54 sub sg13_lv_nmos w=1u l=1u m=1
XT675 vss sub ptap1 A=4e-12 P=8e-6
XM12_52 vb4 vb3 net54 sub sg13_lv_nmos w=1u l=1u m=1
XT676 vss sub ptap1 A=4e-12 P=8e-6
XM12_53 vb4 vb3 net54 sub sg13_lv_nmos w=1u l=1u m=1
XT677 vss sub ptap1 A=4e-12 P=8e-6
XM12_54 vb4 vb3 net54 sub sg13_lv_nmos w=1u l=1u m=1
XT678 vss sub ptap1 A=4e-12 P=8e-6
XM12_55 vb4 vb3 net54 sub sg13_lv_nmos w=1u l=1u m=1
XT679 vss sub ptap1 A=4e-12 P=8e-6
XM12_56 vb4 vb3 net54 sub sg13_lv_nmos w=1u l=1u m=1
XT680 vss sub ptap1 A=4e-12 P=8e-6
XM12_57 vb4 vb3 net54 sub sg13_lv_nmos w=1u l=1u m=1
XT681 vss sub ptap1 A=4e-12 P=8e-6
XM12_58 vb4 vb3 net54 sub sg13_lv_nmos w=1u l=1u m=1
XT682 vss sub ptap1 A=4e-12 P=8e-6
XM12_59 vb4 vb3 net54 sub sg13_lv_nmos w=1u l=1u m=1
XT683 vss sub ptap1 A=4e-12 P=8e-6
XM12_60 vb4 vb3 net54 sub sg13_lv_nmos w=1u l=1u m=1
XT684 vss sub ptap1 A=4e-12 P=8e-6
XM12_61 vb4 vb3 net54 sub sg13_lv_nmos w=1u l=1u m=1
XT685 vss sub ptap1 A=4e-12 P=8e-6
XM12_62 vb4 vb3 net54 sub sg13_lv_nmos w=1u l=1u m=1
XT686 vss sub ptap1 A=4e-12 P=8e-6
XM12_63 vb4 vb3 net54 sub sg13_lv_nmos w=1u l=1u m=1
XT687 vss sub ptap1 A=4e-12 P=8e-6
XM12_64 vb4 vb3 net54 sub sg13_lv_nmos w=1u l=1u m=1
XT688 vss sub ptap1 A=4e-12 P=8e-6
XM12_65 vb4 vb3 net54 sub sg13_lv_nmos w=1u l=1u m=1
XT689 vss sub ptap1 A=4e-12 P=8e-6
XM12_66 vb4 vb3 net54 sub sg13_lv_nmos w=1u l=1u m=1
XT690 vss sub ptap1 A=4e-12 P=8e-6
XM12_67 vb4 vb3 net54 sub sg13_lv_nmos w=1u l=1u m=1
XT691 vss sub ptap1 A=4e-12 P=8e-6
XM12_68 vb4 vb3 net54 sub sg13_lv_nmos w=1u l=1u m=1
XT692 vss sub ptap1 A=4e-12 P=8e-6
XM12_69 vb4 vb3 net54 sub sg13_lv_nmos w=1u l=1u m=1
XT693 vss sub ptap1 A=4e-12 P=8e-6
XM12_70 vb4 vb3 net54 sub sg13_lv_nmos w=1u l=1u m=1
XT694 vss sub ptap1 A=4e-12 P=8e-6
XM12_71 vb4 vb3 net54 sub sg13_lv_nmos w=1u l=1u m=1
XT695 vss sub ptap1 A=4e-12 P=8e-6
XM12_72 vb4 vb3 net54 sub sg13_lv_nmos w=1u l=1u m=1
XT696 vss sub ptap1 A=4e-12 P=8e-6
XM12_73 vb4 vb3 net54 sub sg13_lv_nmos w=1u l=1u m=1
XT697 vss sub ptap1 A=4e-12 P=8e-6
XM12_74 vb4 vb3 net54 sub sg13_lv_nmos w=1u l=1u m=1
XT698 vss sub ptap1 A=4e-12 P=8e-6
XM12_75 vb4 vb3 net54 sub sg13_lv_nmos w=1u l=1u m=1
XT699 vss sub ptap1 A=4e-12 P=8e-6
XM12_76 vb4 vb3 net54 sub sg13_lv_nmos w=1u l=1u m=1
XT700 vss sub ptap1 A=4e-12 P=8e-6
XM12_77 vb4 vb3 net54 sub sg13_lv_nmos w=1u l=1u m=1
XT701 vss sub ptap1 A=4e-12 P=8e-6
XM12_78 vb4 vb3 net54 sub sg13_lv_nmos w=1u l=1u m=1
XT702 vss sub ptap1 A=4e-12 P=8e-6
XM12_79 vb4 vb3 net54 sub sg13_lv_nmos w=1u l=1u m=1
XT703 vss sub ptap1 A=4e-12 P=8e-6
XM13_0 dm_1 vb3 net56 sub sg13_lv_nmos w=1u l=1u m=1
XT704 vss sub ptap1 A=4e-12 P=8e-6
XM13_1 dm_1 vb3 net56 sub sg13_lv_nmos w=1u l=1u m=1
XT705 vss sub ptap1 A=4e-12 P=8e-6
XM13_2 dm_1 vb3 net56 sub sg13_lv_nmos w=1u l=1u m=1
XT706 vss sub ptap1 A=4e-12 P=8e-6
XM13_3 dm_1 vb3 net56 sub sg13_lv_nmos w=1u l=1u m=1
XT707 vss sub ptap1 A=4e-12 P=8e-6
XM13_4 dm_1 vb3 net56 sub sg13_lv_nmos w=1u l=1u m=1
XT708 vss sub ptap1 A=4e-12 P=8e-6
XM13_5 dm_1 vb3 net56 sub sg13_lv_nmos w=1u l=1u m=1
XT709 vss sub ptap1 A=4e-12 P=8e-6
XM13_6 dm_1 vb3 net56 sub sg13_lv_nmos w=1u l=1u m=1
XT710 vss sub ptap1 A=4e-12 P=8e-6
XM13_7 dm_1 vb3 net56 sub sg13_lv_nmos w=1u l=1u m=1
XT711 vss sub ptap1 A=4e-12 P=8e-6
XM13_8 dm_1 vb3 net56 sub sg13_lv_nmos w=1u l=1u m=1
XT712 vss sub ptap1 A=4e-12 P=8e-6
XM13_9 dm_1 vb3 net56 sub sg13_lv_nmos w=1u l=1u m=1
XT713 vss sub ptap1 A=4e-12 P=8e-6
XM13_10 dm_1 vb3 net56 sub sg13_lv_nmos w=1u l=1u m=1
XT714 vss sub ptap1 A=4e-12 P=8e-6
XM13_11 dm_1 vb3 net56 sub sg13_lv_nmos w=1u l=1u m=1
XT715 vss sub ptap1 A=4e-12 P=8e-6
XM13_12 dm_1 vb3 net56 sub sg13_lv_nmos w=1u l=1u m=1
XT716 vss sub ptap1 A=4e-12 P=8e-6
XM13_13 dm_1 vb3 net56 sub sg13_lv_nmos w=1u l=1u m=1
XT717 vss sub ptap1 A=4e-12 P=8e-6
XM13_14 dm_1 vb3 net56 sub sg13_lv_nmos w=1u l=1u m=1
XT718 vss sub ptap1 A=4e-12 P=8e-6
XM13_15 dm_1 vb3 net56 sub sg13_lv_nmos w=1u l=1u m=1
XT719 vss sub ptap1 A=4e-12 P=8e-6
XM13_16 dm_1 vb3 net56 sub sg13_lv_nmos w=1u l=1u m=1
XT720 vss sub ptap1 A=4e-12 P=8e-6
XM13_17 dm_1 vb3 net56 sub sg13_lv_nmos w=1u l=1u m=1
XT721 vss sub ptap1 A=4e-12 P=8e-6
XM13_18 dm_1 vb3 net56 sub sg13_lv_nmos w=1u l=1u m=1
XT722 vss sub ptap1 A=4e-12 P=8e-6
XM13_19 dm_1 vb3 net56 sub sg13_lv_nmos w=1u l=1u m=1
XT723 vss sub ptap1 A=4e-12 P=8e-6
XM13_20 dm_1 vb3 net56 sub sg13_lv_nmos w=1u l=1u m=1
XT724 vss sub ptap1 A=4e-12 P=8e-6
XM13_21 dm_1 vb3 net56 sub sg13_lv_nmos w=1u l=1u m=1
XT725 vss sub ptap1 A=4e-12 P=8e-6
XM13_22 dm_1 vb3 net56 sub sg13_lv_nmos w=1u l=1u m=1
XT726 vss sub ptap1 A=4e-12 P=8e-6
XM13_23 dm_1 vb3 net56 sub sg13_lv_nmos w=1u l=1u m=1
XT727 vss sub ptap1 A=4e-12 P=8e-6
XM13_24 dm_1 vb3 net56 sub sg13_lv_nmos w=1u l=1u m=1
XT728 vss sub ptap1 A=4e-12 P=8e-6
XM13_25 dm_1 vb3 net56 sub sg13_lv_nmos w=1u l=1u m=1
XT729 vss sub ptap1 A=4e-12 P=8e-6
XM13_26 dm_1 vb3 net56 sub sg13_lv_nmos w=1u l=1u m=1
XT730 vss sub ptap1 A=4e-12 P=8e-6
XM13_27 dm_1 vb3 net56 sub sg13_lv_nmos w=1u l=1u m=1
XT731 vss sub ptap1 A=4e-12 P=8e-6
XM13_28 dm_1 vb3 net56 sub sg13_lv_nmos w=1u l=1u m=1
XT732 vss sub ptap1 A=4e-12 P=8e-6
XM13_29 dm_1 vb3 net56 sub sg13_lv_nmos w=1u l=1u m=1
XT733 vss sub ptap1 A=4e-12 P=8e-6
XM13_30 dm_1 vb3 net56 sub sg13_lv_nmos w=1u l=1u m=1
XT734 vss sub ptap1 A=4e-12 P=8e-6
XM13_31 dm_1 vb3 net56 sub sg13_lv_nmos w=1u l=1u m=1
XT735 vss sub ptap1 A=4e-12 P=8e-6
XM13_32 dm_1 vb3 net56 sub sg13_lv_nmos w=1u l=1u m=1
XT736 vss sub ptap1 A=4e-12 P=8e-6
XM13_33 dm_1 vb3 net56 sub sg13_lv_nmos w=1u l=1u m=1
XT737 vss sub ptap1 A=4e-12 P=8e-6
XM13_34 dm_1 vb3 net56 sub sg13_lv_nmos w=1u l=1u m=1
XT738 vss sub ptap1 A=4e-12 P=8e-6
XM13_35 dm_1 vb3 net56 sub sg13_lv_nmos w=1u l=1u m=1
XT739 vss sub ptap1 A=4e-12 P=8e-6
XM13_36 dm_1 vb3 net56 sub sg13_lv_nmos w=1u l=1u m=1
XT740 vss sub ptap1 A=4e-12 P=8e-6
XM13_37 dm_1 vb3 net56 sub sg13_lv_nmos w=1u l=1u m=1
XT741 vss sub ptap1 A=4e-12 P=8e-6
XM13_38 dm_1 vb3 net56 sub sg13_lv_nmos w=1u l=1u m=1
XT742 vss sub ptap1 A=4e-12 P=8e-6
XM13_39 dm_1 vb3 net56 sub sg13_lv_nmos w=1u l=1u m=1
XT743 vss sub ptap1 A=4e-12 P=8e-6
XM13_40 dm_1 vb3 net56 sub sg13_lv_nmos w=1u l=1u m=1
XT744 vss sub ptap1 A=4e-12 P=8e-6
XM13_41 dm_1 vb3 net56 sub sg13_lv_nmos w=1u l=1u m=1
XT745 vss sub ptap1 A=4e-12 P=8e-6
XM13_42 dm_1 vb3 net56 sub sg13_lv_nmos w=1u l=1u m=1
XT746 vss sub ptap1 A=4e-12 P=8e-6
XM13_43 dm_1 vb3 net56 sub sg13_lv_nmos w=1u l=1u m=1
XT747 vss sub ptap1 A=4e-12 P=8e-6
XM13_44 dm_1 vb3 net56 sub sg13_lv_nmos w=1u l=1u m=1
XT748 vss sub ptap1 A=4e-12 P=8e-6
XM13_45 dm_1 vb3 net56 sub sg13_lv_nmos w=1u l=1u m=1
XT749 vss sub ptap1 A=4e-12 P=8e-6
XM13_46 dm_1 vb3 net56 sub sg13_lv_nmos w=1u l=1u m=1
XT750 vss sub ptap1 A=4e-12 P=8e-6
XM13_47 dm_1 vb3 net56 sub sg13_lv_nmos w=1u l=1u m=1
XT751 vss sub ptap1 A=4e-12 P=8e-6
XM13_48 dm_1 vb3 net56 sub sg13_lv_nmos w=1u l=1u m=1
XT752 vss sub ptap1 A=4e-12 P=8e-6
XM13_49 dm_1 vb3 net56 sub sg13_lv_nmos w=1u l=1u m=1
XT753 vss sub ptap1 A=4e-12 P=8e-6
XM13_50 dm_1 vb3 net56 sub sg13_lv_nmos w=1u l=1u m=1
XT754 vss sub ptap1 A=4e-12 P=8e-6
XM13_51 dm_1 vb3 net56 sub sg13_lv_nmos w=1u l=1u m=1
XT755 vss sub ptap1 A=4e-12 P=8e-6
XM13_52 dm_1 vb3 net56 sub sg13_lv_nmos w=1u l=1u m=1
XT756 vss sub ptap1 A=4e-12 P=8e-6
XM13_53 dm_1 vb3 net56 sub sg13_lv_nmos w=1u l=1u m=1
XT757 vss sub ptap1 A=4e-12 P=8e-6
XM13_54 dm_1 vb3 net56 sub sg13_lv_nmos w=1u l=1u m=1
XT758 vss sub ptap1 A=4e-12 P=8e-6
XM13_55 dm_1 vb3 net56 sub sg13_lv_nmos w=1u l=1u m=1
XT759 vss sub ptap1 A=4e-12 P=8e-6
XM13_56 dm_1 vb3 net56 sub sg13_lv_nmos w=1u l=1u m=1
XT760 vss sub ptap1 A=4e-12 P=8e-6
XM13_57 dm_1 vb3 net56 sub sg13_lv_nmos w=1u l=1u m=1
XT761 vss sub ptap1 A=4e-12 P=8e-6
XM13_58 dm_1 vb3 net56 sub sg13_lv_nmos w=1u l=1u m=1
XT762 vss sub ptap1 A=4e-12 P=8e-6
XM13_59 dm_1 vb3 net56 sub sg13_lv_nmos w=1u l=1u m=1
XT763 vss sub ptap1 A=4e-12 P=8e-6
XM13_60 dm_1 vb3 net56 sub sg13_lv_nmos w=1u l=1u m=1
XT764 vss sub ptap1 A=4e-12 P=8e-6
XM13_61 dm_1 vb3 net56 sub sg13_lv_nmos w=1u l=1u m=1
XT765 vss sub ptap1 A=4e-12 P=8e-6
XM13_62 dm_1 vb3 net56 sub sg13_lv_nmos w=1u l=1u m=1
XT766 vss sub ptap1 A=4e-12 P=8e-6
XM13_63 dm_1 vb3 net56 sub sg13_lv_nmos w=1u l=1u m=1
XT767 vss sub ptap1 A=4e-12 P=8e-6
XM13_64 dm_1 vb3 net56 sub sg13_lv_nmos w=1u l=1u m=1
XT768 vss sub ptap1 A=4e-12 P=8e-6
XM13_65 dm_1 vb3 net56 sub sg13_lv_nmos w=1u l=1u m=1
XT769 vss sub ptap1 A=4e-12 P=8e-6
XM13_66 dm_1 vb3 net56 sub sg13_lv_nmos w=1u l=1u m=1
XT770 vss sub ptap1 A=4e-12 P=8e-6
XM13_67 dm_1 vb3 net56 sub sg13_lv_nmos w=1u l=1u m=1
XT771 vss sub ptap1 A=4e-12 P=8e-6
XM13_68 dm_1 vb3 net56 sub sg13_lv_nmos w=1u l=1u m=1
XT772 vss sub ptap1 A=4e-12 P=8e-6
XM13_69 dm_1 vb3 net56 sub sg13_lv_nmos w=1u l=1u m=1
XT773 vss sub ptap1 A=4e-12 P=8e-6
XM13_70 dm_1 vb3 net56 sub sg13_lv_nmos w=1u l=1u m=1
XT774 vss sub ptap1 A=4e-12 P=8e-6
XM13_71 dm_1 vb3 net56 sub sg13_lv_nmos w=1u l=1u m=1
XT775 vss sub ptap1 A=4e-12 P=8e-6
XM13_72 dm_1 vb3 net56 sub sg13_lv_nmos w=1u l=1u m=1
XT776 vss sub ptap1 A=4e-12 P=8e-6
XM13_73 dm_1 vb3 net56 sub sg13_lv_nmos w=1u l=1u m=1
XT777 vss sub ptap1 A=4e-12 P=8e-6
XM13_74 dm_1 vb3 net56 sub sg13_lv_nmos w=1u l=1u m=1
XT778 vss sub ptap1 A=4e-12 P=8e-6
XM13_75 dm_1 vb3 net56 sub sg13_lv_nmos w=1u l=1u m=1
XT779 vss sub ptap1 A=4e-12 P=8e-6
XM13_76 dm_1 vb3 net56 sub sg13_lv_nmos w=1u l=1u m=1
XT780 vss sub ptap1 A=4e-12 P=8e-6
XM13_77 dm_1 vb3 net56 sub sg13_lv_nmos w=1u l=1u m=1
XT781 vss sub ptap1 A=4e-12 P=8e-6
XM13_78 dm_1 vb3 net56 sub sg13_lv_nmos w=1u l=1u m=1
XT782 vss sub ptap1 A=4e-12 P=8e-6
XM13_79 dm_1 vb3 net56 sub sg13_lv_nmos w=1u l=1u m=1
XT783 vss sub ptap1 A=4e-12 P=8e-6
XM14_0 vb3 vb3 vss sub sg13_lv_nmos w=1u l=1u m=1
XT784 vss sub ptap1 A=4e-12 P=8e-6
XM14_1 vb3 vb3 vss sub sg13_lv_nmos w=1u l=1u m=1
XT785 vss sub ptap1 A=4e-12 P=8e-6
XM14_2 vb3 vb3 vss sub sg13_lv_nmos w=1u l=1u m=1
XT786 vss sub ptap1 A=4e-12 P=8e-6
XM14_3 vb3 vb3 vss sub sg13_lv_nmos w=1u l=1u m=1
XT787 vss sub ptap1 A=4e-12 P=8e-6
XM14_4 vb3 vb3 vss sub sg13_lv_nmos w=1u l=1u m=1
XT788 vss sub ptap1 A=4e-12 P=8e-6
XM14_5 vb3 vb3 vss sub sg13_lv_nmos w=1u l=1u m=1
XT789 vss sub ptap1 A=4e-12 P=8e-6
XM14_6 vb3 vb3 vss sub sg13_lv_nmos w=1u l=1u m=1
XT790 vss sub ptap1 A=4e-12 P=8e-6
XM14_7 vb3 vb3 vss sub sg13_lv_nmos w=1u l=1u m=1
XT791 vss sub ptap1 A=4e-12 P=8e-6
XM14_8 vb3 vb3 vss sub sg13_lv_nmos w=1u l=1u m=1
XT792 vss sub ptap1 A=4e-12 P=8e-6
XM14_9 vb3 vb3 vss sub sg13_lv_nmos w=1u l=1u m=1
XT793 vss sub ptap1 A=4e-12 P=8e-6
XM14_10 vb3 vb3 vss sub sg13_lv_nmos w=1u l=1u m=1
XT794 vss sub ptap1 A=4e-12 P=8e-6
XM14_11 vb3 vb3 vss sub sg13_lv_nmos w=1u l=1u m=1
XT795 vss sub ptap1 A=4e-12 P=8e-6
XM14_12 vb3 vb3 vss sub sg13_lv_nmos w=1u l=1u m=1
XT796 vss sub ptap1 A=4e-12 P=8e-6
XM14_13 vb3 vb3 vss sub sg13_lv_nmos w=1u l=1u m=1
XT797 vss sub ptap1 A=4e-12 P=8e-6
XM14_14 vb3 vb3 vss sub sg13_lv_nmos w=1u l=1u m=1
XT798 vss sub ptap1 A=4e-12 P=8e-6
XM14_15 vb3 vb3 vss sub sg13_lv_nmos w=1u l=1u m=1
XT799 vss sub ptap1 A=4e-12 P=8e-6
XM14_16 vb3 vb3 vss sub sg13_lv_nmos w=1u l=1u m=1
XT800 vss sub ptap1 A=4e-12 P=8e-6
XM14_17 vb3 vb3 vss sub sg13_lv_nmos w=1u l=1u m=1
XT801 vss sub ptap1 A=4e-12 P=8e-6
XM14_18 vb3 vb3 vss sub sg13_lv_nmos w=1u l=1u m=1
XT802 vss sub ptap1 A=4e-12 P=8e-6
XM14_19 vb3 vb3 vss sub sg13_lv_nmos w=1u l=1u m=1
XT803 vss sub ptap1 A=4e-12 P=8e-6
XM15_0 voutn vb3 dm_2 sub sg13_lv_nmos w=1u l=1u m=1
XT804 vss sub ptap1 A=4e-12 P=8e-6
XM15_1 voutn vb3 dm_2 sub sg13_lv_nmos w=1u l=1u m=1
XT805 vss sub ptap1 A=4e-12 P=8e-6
XM15_2 voutn vb3 dm_2 sub sg13_lv_nmos w=1u l=1u m=1
XT806 vss sub ptap1 A=4e-12 P=8e-6
XM15_3 voutn vb3 dm_2 sub sg13_lv_nmos w=1u l=1u m=1
XT807 vss sub ptap1 A=4e-12 P=8e-6
XM15_4 voutn vb3 dm_2 sub sg13_lv_nmos w=1u l=1u m=1
XT808 vss sub ptap1 A=4e-12 P=8e-6
XM15_5 voutn vb3 dm_2 sub sg13_lv_nmos w=1u l=1u m=1
XT809 vss sub ptap1 A=4e-12 P=8e-6
XM15_6 voutn vb3 dm_2 sub sg13_lv_nmos w=1u l=1u m=1
XT810 vss sub ptap1 A=4e-12 P=8e-6
XM15_7 voutn vb3 dm_2 sub sg13_lv_nmos w=1u l=1u m=1
XT811 vss sub ptap1 A=4e-12 P=8e-6
XM15_8 voutn vb3 dm_2 sub sg13_lv_nmos w=1u l=1u m=1
XT812 vss sub ptap1 A=4e-12 P=8e-6
XM15_9 voutn vb3 dm_2 sub sg13_lv_nmos w=1u l=1u m=1
XT813 vss sub ptap1 A=4e-12 P=8e-6
XM15_10 voutn vb3 dm_2 sub sg13_lv_nmos w=1u l=1u m=1
XT814 vss sub ptap1 A=4e-12 P=8e-6
XM15_11 voutn vb3 dm_2 sub sg13_lv_nmos w=1u l=1u m=1
XT815 vss sub ptap1 A=4e-12 P=8e-6
XM15_12 voutn vb3 dm_2 sub sg13_lv_nmos w=1u l=1u m=1
XT816 vss sub ptap1 A=4e-12 P=8e-6
XM15_13 voutn vb3 dm_2 sub sg13_lv_nmos w=1u l=1u m=1
XT817 vss sub ptap1 A=4e-12 P=8e-6
XM15_14 voutn vb3 dm_2 sub sg13_lv_nmos w=1u l=1u m=1
XT818 vss sub ptap1 A=4e-12 P=8e-6
XM15_15 voutn vb3 dm_2 sub sg13_lv_nmos w=1u l=1u m=1
XT819 vss sub ptap1 A=4e-12 P=8e-6
XM15_16 voutn vb3 dm_2 sub sg13_lv_nmos w=1u l=1u m=1
XT820 vss sub ptap1 A=4e-12 P=8e-6
XM15_17 voutn vb3 dm_2 sub sg13_lv_nmos w=1u l=1u m=1
XT821 vss sub ptap1 A=4e-12 P=8e-6
XM15_18 voutn vb3 dm_2 sub sg13_lv_nmos w=1u l=1u m=1
XT822 vss sub ptap1 A=4e-12 P=8e-6
XM15_19 voutn vb3 dm_2 sub sg13_lv_nmos w=1u l=1u m=1
XT823 vss sub ptap1 A=4e-12 P=8e-6
XM15_20 voutn vb3 dm_2 sub sg13_lv_nmos w=1u l=1u m=1
XT824 vss sub ptap1 A=4e-12 P=8e-6
XM15_21 voutn vb3 dm_2 sub sg13_lv_nmos w=1u l=1u m=1
XT825 vss sub ptap1 A=4e-12 P=8e-6
XM15_22 voutn vb3 dm_2 sub sg13_lv_nmos w=1u l=1u m=1
XT826 vss sub ptap1 A=4e-12 P=8e-6
XM15_23 voutn vb3 dm_2 sub sg13_lv_nmos w=1u l=1u m=1
XT827 vss sub ptap1 A=4e-12 P=8e-6
XM15_24 voutn vb3 dm_2 sub sg13_lv_nmos w=1u l=1u m=1
XT828 vss sub ptap1 A=4e-12 P=8e-6
XM15_25 voutn vb3 dm_2 sub sg13_lv_nmos w=1u l=1u m=1
XT829 vss sub ptap1 A=4e-12 P=8e-6
XM15_26 voutn vb3 dm_2 sub sg13_lv_nmos w=1u l=1u m=1
XT830 vss sub ptap1 A=4e-12 P=8e-6
XM15_27 voutn vb3 dm_2 sub sg13_lv_nmos w=1u l=1u m=1
XT831 vss sub ptap1 A=4e-12 P=8e-6
XM15_28 voutn vb3 dm_2 sub sg13_lv_nmos w=1u l=1u m=1
XT832 vss sub ptap1 A=4e-12 P=8e-6
XM15_29 voutn vb3 dm_2 sub sg13_lv_nmos w=1u l=1u m=1
XT833 vss sub ptap1 A=4e-12 P=8e-6
XM15_30 voutn vb3 dm_2 sub sg13_lv_nmos w=1u l=1u m=1
XT834 vss sub ptap1 A=4e-12 P=8e-6
XM15_31 voutn vb3 dm_2 sub sg13_lv_nmos w=1u l=1u m=1
XT835 vss sub ptap1 A=4e-12 P=8e-6
XM15_32 voutn vb3 dm_2 sub sg13_lv_nmos w=1u l=1u m=1
XT836 vss sub ptap1 A=4e-12 P=8e-6
XM15_33 voutn vb3 dm_2 sub sg13_lv_nmos w=1u l=1u m=1
XT837 vss sub ptap1 A=4e-12 P=8e-6
XM15_34 voutn vb3 dm_2 sub sg13_lv_nmos w=1u l=1u m=1
XT838 vss sub ptap1 A=4e-12 P=8e-6
XM15_35 voutn vb3 dm_2 sub sg13_lv_nmos w=1u l=1u m=1
XT839 vss sub ptap1 A=4e-12 P=8e-6
XM15_36 voutn vb3 dm_2 sub sg13_lv_nmos w=1u l=1u m=1
XT840 vss sub ptap1 A=4e-12 P=8e-6
XM15_37 voutn vb3 dm_2 sub sg13_lv_nmos w=1u l=1u m=1
XT841 vss sub ptap1 A=4e-12 P=8e-6
XM15_38 voutn vb3 dm_2 sub sg13_lv_nmos w=1u l=1u m=1
XT842 vss sub ptap1 A=4e-12 P=8e-6
XM15_39 voutn vb3 dm_2 sub sg13_lv_nmos w=1u l=1u m=1
XT843 vss sub ptap1 A=4e-12 P=8e-6
XM15_40 voutn vb3 dm_2 sub sg13_lv_nmos w=1u l=1u m=1
XT844 vss sub ptap1 A=4e-12 P=8e-6
XM15_41 voutn vb3 dm_2 sub sg13_lv_nmos w=1u l=1u m=1
XT845 vss sub ptap1 A=4e-12 P=8e-6
XM15_42 voutn vb3 dm_2 sub sg13_lv_nmos w=1u l=1u m=1
XT846 vss sub ptap1 A=4e-12 P=8e-6
XM15_43 voutn vb3 dm_2 sub sg13_lv_nmos w=1u l=1u m=1
XT847 vss sub ptap1 A=4e-12 P=8e-6
XM15_44 voutn vb3 dm_2 sub sg13_lv_nmos w=1u l=1u m=1
XT848 vss sub ptap1 A=4e-12 P=8e-6
XM15_45 voutn vb3 dm_2 sub sg13_lv_nmos w=1u l=1u m=1
XT849 vss sub ptap1 A=4e-12 P=8e-6
XM15_46 voutn vb3 dm_2 sub sg13_lv_nmos w=1u l=1u m=1
XT850 vss sub ptap1 A=4e-12 P=8e-6
XM15_47 voutn vb3 dm_2 sub sg13_lv_nmos w=1u l=1u m=1
XT851 vss sub ptap1 A=4e-12 P=8e-6
XM15_48 voutn vb3 dm_2 sub sg13_lv_nmos w=1u l=1u m=1
XT852 vss sub ptap1 A=4e-12 P=8e-6
XM15_49 voutn vb3 dm_2 sub sg13_lv_nmos w=1u l=1u m=1
XT853 vss sub ptap1 A=4e-12 P=8e-6
XM15_50 voutn vb3 dm_2 sub sg13_lv_nmos w=1u l=1u m=1
XT854 vss sub ptap1 A=4e-12 P=8e-6
XM15_51 voutn vb3 dm_2 sub sg13_lv_nmos w=1u l=1u m=1
XT855 vss sub ptap1 A=4e-12 P=8e-6
XM15_52 voutn vb3 dm_2 sub sg13_lv_nmos w=1u l=1u m=1
XT856 vss sub ptap1 A=4e-12 P=8e-6
XM15_53 voutn vb3 dm_2 sub sg13_lv_nmos w=1u l=1u m=1
XT857 vss sub ptap1 A=4e-12 P=8e-6
XM15_54 voutn vb3 dm_2 sub sg13_lv_nmos w=1u l=1u m=1
XT858 vss sub ptap1 A=4e-12 P=8e-6
XM15_55 voutn vb3 dm_2 sub sg13_lv_nmos w=1u l=1u m=1
XT859 vss sub ptap1 A=4e-12 P=8e-6
XM15_56 voutn vb3 dm_2 sub sg13_lv_nmos w=1u l=1u m=1
XT860 vss sub ptap1 A=4e-12 P=8e-6
XM15_57 voutn vb3 dm_2 sub sg13_lv_nmos w=1u l=1u m=1
XT861 vss sub ptap1 A=4e-12 P=8e-6
XM15_58 voutn vb3 dm_2 sub sg13_lv_nmos w=1u l=1u m=1
XT862 vss sub ptap1 A=4e-12 P=8e-6
XM15_59 voutn vb3 dm_2 sub sg13_lv_nmos w=1u l=1u m=1
XT863 vss sub ptap1 A=4e-12 P=8e-6
XM15_60 voutn vb3 dm_2 sub sg13_lv_nmos w=1u l=1u m=1
XT864 vss sub ptap1 A=4e-12 P=8e-6
XM15_61 voutn vb3 dm_2 sub sg13_lv_nmos w=1u l=1u m=1
XT865 vss sub ptap1 A=4e-12 P=8e-6
XM15_62 voutn vb3 dm_2 sub sg13_lv_nmos w=1u l=1u m=1
XT866 vss sub ptap1 A=4e-12 P=8e-6
XM15_63 voutn vb3 dm_2 sub sg13_lv_nmos w=1u l=1u m=1
XT867 vss sub ptap1 A=4e-12 P=8e-6
XM15_64 voutn vb3 dm_2 sub sg13_lv_nmos w=1u l=1u m=1
XT868 vss sub ptap1 A=4e-12 P=8e-6
XM15_65 voutn vb3 dm_2 sub sg13_lv_nmos w=1u l=1u m=1
XT869 vss sub ptap1 A=4e-12 P=8e-6
XM15_66 voutn vb3 dm_2 sub sg13_lv_nmos w=1u l=1u m=1
XT870 vss sub ptap1 A=4e-12 P=8e-6
XM15_67 voutn vb3 dm_2 sub sg13_lv_nmos w=1u l=1u m=1
XT871 vss sub ptap1 A=4e-12 P=8e-6
XM15_68 voutn vb3 dm_2 sub sg13_lv_nmos w=1u l=1u m=1
XT872 vss sub ptap1 A=4e-12 P=8e-6
XM15_69 voutn vb3 dm_2 sub sg13_lv_nmos w=1u l=1u m=1
XT873 vss sub ptap1 A=4e-12 P=8e-6
XM15_70 voutn vb3 dm_2 sub sg13_lv_nmos w=1u l=1u m=1
XT874 vss sub ptap1 A=4e-12 P=8e-6
XM15_71 voutn vb3 dm_2 sub sg13_lv_nmos w=1u l=1u m=1
XT875 vss sub ptap1 A=4e-12 P=8e-6
XM15_72 voutn vb3 dm_2 sub sg13_lv_nmos w=1u l=1u m=1
XT876 vss sub ptap1 A=4e-12 P=8e-6
XM15_73 voutn vb3 dm_2 sub sg13_lv_nmos w=1u l=1u m=1
XT877 vss sub ptap1 A=4e-12 P=8e-6
XM15_74 voutn vb3 dm_2 sub sg13_lv_nmos w=1u l=1u m=1
XT878 vss sub ptap1 A=4e-12 P=8e-6
XM15_75 voutn vb3 dm_2 sub sg13_lv_nmos w=1u l=1u m=1
XT879 vss sub ptap1 A=4e-12 P=8e-6
XM15_76 voutn vb3 dm_2 sub sg13_lv_nmos w=1u l=1u m=1
XT880 vss sub ptap1 A=4e-12 P=8e-6
XM15_77 voutn vb3 dm_2 sub sg13_lv_nmos w=1u l=1u m=1
XT881 vss sub ptap1 A=4e-12 P=8e-6
XM15_78 voutn vb3 dm_2 sub sg13_lv_nmos w=1u l=1u m=1
XT882 vss sub ptap1 A=4e-12 P=8e-6
XM15_79 voutn vb3 dm_2 sub sg13_lv_nmos w=1u l=1u m=1
XT883 vss sub ptap1 A=4e-12 P=8e-6
XM16_0 net050 vb3 net063 sub sg13_lv_nmos w=1u l=1u m=1
XT884 vss sub ptap1 A=4e-12 P=8e-6
XM16_1 net050 vb3 net063 sub sg13_lv_nmos w=1u l=1u m=1
XT885 vss sub ptap1 A=4e-12 P=8e-6
XM16_2 net050 vb3 net063 sub sg13_lv_nmos w=1u l=1u m=1
XT886 vss sub ptap1 A=4e-12 P=8e-6
XM16_3 net050 vb3 net063 sub sg13_lv_nmos w=1u l=1u m=1
XT887 vss sub ptap1 A=4e-12 P=8e-6
XM16_4 net050 vb3 net063 sub sg13_lv_nmos w=1u l=1u m=1
XT888 vss sub ptap1 A=4e-12 P=8e-6
XM16_5 net050 vb3 net063 sub sg13_lv_nmos w=1u l=1u m=1
XT889 vss sub ptap1 A=4e-12 P=8e-6
XM16_6 net050 vb3 net063 sub sg13_lv_nmos w=1u l=1u m=1
XT890 vss sub ptap1 A=4e-12 P=8e-6
XM16_7 net050 vb3 net063 sub sg13_lv_nmos w=1u l=1u m=1
XT891 vss sub ptap1 A=4e-12 P=8e-6
XM16_8 net050 vb3 net063 sub sg13_lv_nmos w=1u l=1u m=1
XT892 vss sub ptap1 A=4e-12 P=8e-6
XM16_9 net050 vb3 net063 sub sg13_lv_nmos w=1u l=1u m=1
XT893 vss sub ptap1 A=4e-12 P=8e-6
XM16_10 net050 vb3 net063 sub sg13_lv_nmos w=1u l=1u m=1
XT894 vss sub ptap1 A=4e-12 P=8e-6
XM16_11 net050 vb3 net063 sub sg13_lv_nmos w=1u l=1u m=1
XT895 vss sub ptap1 A=4e-12 P=8e-6
XM16_12 net050 vb3 net063 sub sg13_lv_nmos w=1u l=1u m=1
XT896 vss sub ptap1 A=4e-12 P=8e-6
XM16_13 net050 vb3 net063 sub sg13_lv_nmos w=1u l=1u m=1
XT897 vss sub ptap1 A=4e-12 P=8e-6
XM16_14 net050 vb3 net063 sub sg13_lv_nmos w=1u l=1u m=1
XT898 vss sub ptap1 A=4e-12 P=8e-6
XM16_15 net050 vb3 net063 sub sg13_lv_nmos w=1u l=1u m=1
XT899 vss sub ptap1 A=4e-12 P=8e-6
XM16_16 net050 vb3 net063 sub sg13_lv_nmos w=1u l=1u m=1
XT900 vss sub ptap1 A=4e-12 P=8e-6
XM16_17 net050 vb3 net063 sub sg13_lv_nmos w=1u l=1u m=1
XT901 vss sub ptap1 A=4e-12 P=8e-6
XM16_18 net050 vb3 net063 sub sg13_lv_nmos w=1u l=1u m=1
XT902 vss sub ptap1 A=4e-12 P=8e-6
XM16_19 net050 vb3 net063 sub sg13_lv_nmos w=1u l=1u m=1
XT903 vss sub ptap1 A=4e-12 P=8e-6
XM16_20 net050 vb3 net063 sub sg13_lv_nmos w=1u l=1u m=1
XT904 vss sub ptap1 A=4e-12 P=8e-6
XM16_21 net050 vb3 net063 sub sg13_lv_nmos w=1u l=1u m=1
XT905 vss sub ptap1 A=4e-12 P=8e-6
XM16_22 net050 vb3 net063 sub sg13_lv_nmos w=1u l=1u m=1
XT906 vss sub ptap1 A=4e-12 P=8e-6
XM16_23 net050 vb3 net063 sub sg13_lv_nmos w=1u l=1u m=1
XT907 vss sub ptap1 A=4e-12 P=8e-6
XM16_24 net050 vb3 net063 sub sg13_lv_nmos w=1u l=1u m=1
XT908 vss sub ptap1 A=4e-12 P=8e-6
XM16_25 net050 vb3 net063 sub sg13_lv_nmos w=1u l=1u m=1
XT909 vss sub ptap1 A=4e-12 P=8e-6
XM16_26 net050 vb3 net063 sub sg13_lv_nmos w=1u l=1u m=1
XT910 vss sub ptap1 A=4e-12 P=8e-6
XM16_27 net050 vb3 net063 sub sg13_lv_nmos w=1u l=1u m=1
XT911 vss sub ptap1 A=4e-12 P=8e-6
XM16_28 net050 vb3 net063 sub sg13_lv_nmos w=1u l=1u m=1
XT912 vss sub ptap1 A=4e-12 P=8e-6
XM16_29 net050 vb3 net063 sub sg13_lv_nmos w=1u l=1u m=1
XT913 vss sub ptap1 A=4e-12 P=8e-6
XM16_30 net050 vb3 net063 sub sg13_lv_nmos w=1u l=1u m=1
XT914 vss sub ptap1 A=4e-12 P=8e-6
XM16_31 net050 vb3 net063 sub sg13_lv_nmos w=1u l=1u m=1
XT915 vss sub ptap1 A=4e-12 P=8e-6
XM16_32 net050 vb3 net063 sub sg13_lv_nmos w=1u l=1u m=1
XT916 vss sub ptap1 A=4e-12 P=8e-6
XM16_33 net050 vb3 net063 sub sg13_lv_nmos w=1u l=1u m=1
XT917 vss sub ptap1 A=4e-12 P=8e-6
XM16_34 net050 vb3 net063 sub sg13_lv_nmos w=1u l=1u m=1
XT918 vss sub ptap1 A=4e-12 P=8e-6
XM16_35 net050 vb3 net063 sub sg13_lv_nmos w=1u l=1u m=1
XT919 vss sub ptap1 A=4e-12 P=8e-6
XM16_36 net050 vb3 net063 sub sg13_lv_nmos w=1u l=1u m=1
XT920 vss sub ptap1 A=4e-12 P=8e-6
XM16_37 net050 vb3 net063 sub sg13_lv_nmos w=1u l=1u m=1
XT921 vss sub ptap1 A=4e-12 P=8e-6
XM16_38 net050 vb3 net063 sub sg13_lv_nmos w=1u l=1u m=1
XT922 vss sub ptap1 A=4e-12 P=8e-6
XM16_39 net050 vb3 net063 sub sg13_lv_nmos w=1u l=1u m=1
XT923 vss sub ptap1 A=4e-12 P=8e-6
XM16_40 net050 vb3 net063 sub sg13_lv_nmos w=1u l=1u m=1
XT924 vss sub ptap1 A=4e-12 P=8e-6
XM16_41 net050 vb3 net063 sub sg13_lv_nmos w=1u l=1u m=1
XT925 vss sub ptap1 A=4e-12 P=8e-6
XM16_42 net050 vb3 net063 sub sg13_lv_nmos w=1u l=1u m=1
XT926 vss sub ptap1 A=4e-12 P=8e-6
XM16_43 net050 vb3 net063 sub sg13_lv_nmos w=1u l=1u m=1
XT927 vss sub ptap1 A=4e-12 P=8e-6
XM16_44 net050 vb3 net063 sub sg13_lv_nmos w=1u l=1u m=1
XT928 vss sub ptap1 A=4e-12 P=8e-6
XM16_45 net050 vb3 net063 sub sg13_lv_nmos w=1u l=1u m=1
XT929 vss sub ptap1 A=4e-12 P=8e-6
XM16_46 net050 vb3 net063 sub sg13_lv_nmos w=1u l=1u m=1
XT930 vss sub ptap1 A=4e-12 P=8e-6
XM16_47 net050 vb3 net063 sub sg13_lv_nmos w=1u l=1u m=1
XT931 vss sub ptap1 A=4e-12 P=8e-6
XM16_48 net050 vb3 net063 sub sg13_lv_nmos w=1u l=1u m=1
XT932 vss sub ptap1 A=4e-12 P=8e-6
XM16_49 net050 vb3 net063 sub sg13_lv_nmos w=1u l=1u m=1
XT933 vss sub ptap1 A=4e-12 P=8e-6
XM16_50 net050 vb3 net063 sub sg13_lv_nmos w=1u l=1u m=1
XT934 vss sub ptap1 A=4e-12 P=8e-6
XM16_51 net050 vb3 net063 sub sg13_lv_nmos w=1u l=1u m=1
XT935 vss sub ptap1 A=4e-12 P=8e-6
XM16_52 net050 vb3 net063 sub sg13_lv_nmos w=1u l=1u m=1
XT936 vss sub ptap1 A=4e-12 P=8e-6
XM16_53 net050 vb3 net063 sub sg13_lv_nmos w=1u l=1u m=1
XT937 vss sub ptap1 A=4e-12 P=8e-6
XM16_54 net050 vb3 net063 sub sg13_lv_nmos w=1u l=1u m=1
XT938 vss sub ptap1 A=4e-12 P=8e-6
XM16_55 net050 vb3 net063 sub sg13_lv_nmos w=1u l=1u m=1
XT939 vss sub ptap1 A=4e-12 P=8e-6
XM16_56 net050 vb3 net063 sub sg13_lv_nmos w=1u l=1u m=1
XT940 vss sub ptap1 A=4e-12 P=8e-6
XM16_57 net050 vb3 net063 sub sg13_lv_nmos w=1u l=1u m=1
XT941 vss sub ptap1 A=4e-12 P=8e-6
XM16_58 net050 vb3 net063 sub sg13_lv_nmos w=1u l=1u m=1
XT942 vss sub ptap1 A=4e-12 P=8e-6
XM16_59 net050 vb3 net063 sub sg13_lv_nmos w=1u l=1u m=1
XT943 vss sub ptap1 A=4e-12 P=8e-6
XM16_60 net050 vb3 net063 sub sg13_lv_nmos w=1u l=1u m=1
XT944 vss sub ptap1 A=4e-12 P=8e-6
XM16_61 net050 vb3 net063 sub sg13_lv_nmos w=1u l=1u m=1
XT945 vss sub ptap1 A=4e-12 P=8e-6
XM16_62 net050 vb3 net063 sub sg13_lv_nmos w=1u l=1u m=1
XT946 vss sub ptap1 A=4e-12 P=8e-6
XM16_63 net050 vb3 net063 sub sg13_lv_nmos w=1u l=1u m=1
XT947 vss sub ptap1 A=4e-12 P=8e-6
XM16_64 net050 vb3 net063 sub sg13_lv_nmos w=1u l=1u m=1
XT948 vss sub ptap1 A=4e-12 P=8e-6
XM16_65 net050 vb3 net063 sub sg13_lv_nmos w=1u l=1u m=1
XT949 vss sub ptap1 A=4e-12 P=8e-6
XM16_66 net050 vb3 net063 sub sg13_lv_nmos w=1u l=1u m=1
XT950 vss sub ptap1 A=4e-12 P=8e-6
XM16_67 net050 vb3 net063 sub sg13_lv_nmos w=1u l=1u m=1
XT951 vss sub ptap1 A=4e-12 P=8e-6
XM16_68 net050 vb3 net063 sub sg13_lv_nmos w=1u l=1u m=1
XT952 vss sub ptap1 A=4e-12 P=8e-6
XM16_69 net050 vb3 net063 sub sg13_lv_nmos w=1u l=1u m=1
XT953 vss sub ptap1 A=4e-12 P=8e-6
XM16_70 net050 vb3 net063 sub sg13_lv_nmos w=1u l=1u m=1
XT954 vss sub ptap1 A=4e-12 P=8e-6
XM16_71 net050 vb3 net063 sub sg13_lv_nmos w=1u l=1u m=1
XT955 vss sub ptap1 A=4e-12 P=8e-6
XM16_72 net050 vb3 net063 sub sg13_lv_nmos w=1u l=1u m=1
XT956 vss sub ptap1 A=4e-12 P=8e-6
XM16_73 net050 vb3 net063 sub sg13_lv_nmos w=1u l=1u m=1
XT957 vss sub ptap1 A=4e-12 P=8e-6
XM16_74 net050 vb3 net063 sub sg13_lv_nmos w=1u l=1u m=1
XT958 vss sub ptap1 A=4e-12 P=8e-6
XM16_75 net050 vb3 net063 sub sg13_lv_nmos w=1u l=1u m=1
XT959 vss sub ptap1 A=4e-12 P=8e-6
XM16_76 net050 vb3 net063 sub sg13_lv_nmos w=1u l=1u m=1
XT960 vss sub ptap1 A=4e-12 P=8e-6
XM16_77 net050 vb3 net063 sub sg13_lv_nmos w=1u l=1u m=1
XT961 vss sub ptap1 A=4e-12 P=8e-6
XM16_78 net050 vb3 net063 sub sg13_lv_nmos w=1u l=1u m=1
XT962 vss sub ptap1 A=4e-12 P=8e-6
XM16_79 net050 vb3 net063 sub sg13_lv_nmos w=1u l=1u m=1
XT963 vss sub ptap1 A=4e-12 P=8e-6
XM17_0 net54 vb4 vss sub sg13_lv_nmos w=1u l=1u m=1
XT964 vss sub ptap1 A=4e-12 P=8e-6
XM17_1 net54 vb4 vss sub sg13_lv_nmos w=1u l=1u m=1
XT965 vss sub ptap1 A=4e-12 P=8e-6
XM17_2 net54 vb4 vss sub sg13_lv_nmos w=1u l=1u m=1
XT966 vss sub ptap1 A=4e-12 P=8e-6
XM17_3 net54 vb4 vss sub sg13_lv_nmos w=1u l=1u m=1
XT967 vss sub ptap1 A=4e-12 P=8e-6
XM17_4 net54 vb4 vss sub sg13_lv_nmos w=1u l=1u m=1
XT968 vss sub ptap1 A=4e-12 P=8e-6
XM17_5 net54 vb4 vss sub sg13_lv_nmos w=1u l=1u m=1
XT969 vss sub ptap1 A=4e-12 P=8e-6
XM17_6 net54 vb4 vss sub sg13_lv_nmos w=1u l=1u m=1
XT970 vss sub ptap1 A=4e-12 P=8e-6
XM17_7 net54 vb4 vss sub sg13_lv_nmos w=1u l=1u m=1
XT971 vss sub ptap1 A=4e-12 P=8e-6
XM17_8 net54 vb4 vss sub sg13_lv_nmos w=1u l=1u m=1
XT972 vss sub ptap1 A=4e-12 P=8e-6
XM17_9 net54 vb4 vss sub sg13_lv_nmos w=1u l=1u m=1
XT973 vss sub ptap1 A=4e-12 P=8e-6
XM17_10 net54 vb4 vss sub sg13_lv_nmos w=1u l=1u m=1
XT974 vss sub ptap1 A=4e-12 P=8e-6
XM17_11 net54 vb4 vss sub sg13_lv_nmos w=1u l=1u m=1
XT975 vss sub ptap1 A=4e-12 P=8e-6
XM17_12 net54 vb4 vss sub sg13_lv_nmos w=1u l=1u m=1
XT976 vss sub ptap1 A=4e-12 P=8e-6
XM17_13 net54 vb4 vss sub sg13_lv_nmos w=1u l=1u m=1
XT977 vss sub ptap1 A=4e-12 P=8e-6
XM17_14 net54 vb4 vss sub sg13_lv_nmos w=1u l=1u m=1
XT978 vss sub ptap1 A=4e-12 P=8e-6
XM17_15 net54 vb4 vss sub sg13_lv_nmos w=1u l=1u m=1
XT979 vss sub ptap1 A=4e-12 P=8e-6
XM17_16 net54 vb4 vss sub sg13_lv_nmos w=1u l=1u m=1
XT980 vss sub ptap1 A=4e-12 P=8e-6
XM17_17 net54 vb4 vss sub sg13_lv_nmos w=1u l=1u m=1
XT981 vss sub ptap1 A=4e-12 P=8e-6
XM17_18 net54 vb4 vss sub sg13_lv_nmos w=1u l=1u m=1
XT982 vss sub ptap1 A=4e-12 P=8e-6
XM17_19 net54 vb4 vss sub sg13_lv_nmos w=1u l=1u m=1
XT983 vss sub ptap1 A=4e-12 P=8e-6
XM17_20 net54 vb4 vss sub sg13_lv_nmos w=1u l=1u m=1
XT984 vss sub ptap1 A=4e-12 P=8e-6
XM17_21 net54 vb4 vss sub sg13_lv_nmos w=1u l=1u m=1
XT985 vss sub ptap1 A=4e-12 P=8e-6
XM17_22 net54 vb4 vss sub sg13_lv_nmos w=1u l=1u m=1
XT986 vss sub ptap1 A=4e-12 P=8e-6
XM17_23 net54 vb4 vss sub sg13_lv_nmos w=1u l=1u m=1
XT987 vss sub ptap1 A=4e-12 P=8e-6
XM17_24 net54 vb4 vss sub sg13_lv_nmos w=1u l=1u m=1
XT988 vss sub ptap1 A=4e-12 P=8e-6
XM17_25 net54 vb4 vss sub sg13_lv_nmos w=1u l=1u m=1
XT989 vss sub ptap1 A=4e-12 P=8e-6
XM17_26 net54 vb4 vss sub sg13_lv_nmos w=1u l=1u m=1
XT990 vss sub ptap1 A=4e-12 P=8e-6
XM17_27 net54 vb4 vss sub sg13_lv_nmos w=1u l=1u m=1
XT991 vss sub ptap1 A=4e-12 P=8e-6
XM17_28 net54 vb4 vss sub sg13_lv_nmos w=1u l=1u m=1
XT992 vss sub ptap1 A=4e-12 P=8e-6
XM17_29 net54 vb4 vss sub sg13_lv_nmos w=1u l=1u m=1
XT993 vss sub ptap1 A=4e-12 P=8e-6
XM17_30 net54 vb4 vss sub sg13_lv_nmos w=1u l=1u m=1
XT994 vss sub ptap1 A=4e-12 P=8e-6
XM17_31 net54 vb4 vss sub sg13_lv_nmos w=1u l=1u m=1
XT995 vss sub ptap1 A=4e-12 P=8e-6
XM17_32 net54 vb4 vss sub sg13_lv_nmos w=1u l=1u m=1
XT996 vss sub ptap1 A=4e-12 P=8e-6
XM17_33 net54 vb4 vss sub sg13_lv_nmos w=1u l=1u m=1
XT997 vss sub ptap1 A=4e-12 P=8e-6
XM17_34 net54 vb4 vss sub sg13_lv_nmos w=1u l=1u m=1
XT998 vss sub ptap1 A=4e-12 P=8e-6
XM17_35 net54 vb4 vss sub sg13_lv_nmos w=1u l=1u m=1
XT999 vss sub ptap1 A=4e-12 P=8e-6
XM17_36 net54 vb4 vss sub sg13_lv_nmos w=1u l=1u m=1
XT1000 vss sub ptap1 A=4e-12 P=8e-6
XM17_37 net54 vb4 vss sub sg13_lv_nmos w=1u l=1u m=1
XT1001 vss sub ptap1 A=4e-12 P=8e-6
XM17_38 net54 vb4 vss sub sg13_lv_nmos w=1u l=1u m=1
XT1002 vss sub ptap1 A=4e-12 P=8e-6
XM17_39 net54 vb4 vss sub sg13_lv_nmos w=1u l=1u m=1
XT1003 vss sub ptap1 A=4e-12 P=8e-6
XM17_40 net54 vb4 vss sub sg13_lv_nmos w=1u l=1u m=1
XT1004 vss sub ptap1 A=4e-12 P=8e-6
XM17_41 net54 vb4 vss sub sg13_lv_nmos w=1u l=1u m=1
XT1005 vss sub ptap1 A=4e-12 P=8e-6
XM17_42 net54 vb4 vss sub sg13_lv_nmos w=1u l=1u m=1
XT1006 vss sub ptap1 A=4e-12 P=8e-6
XM17_43 net54 vb4 vss sub sg13_lv_nmos w=1u l=1u m=1
XT1007 vss sub ptap1 A=4e-12 P=8e-6
XM17_44 net54 vb4 vss sub sg13_lv_nmos w=1u l=1u m=1
XT1008 vss sub ptap1 A=4e-12 P=8e-6
XM17_45 net54 vb4 vss sub sg13_lv_nmos w=1u l=1u m=1
XT1009 vss sub ptap1 A=4e-12 P=8e-6
XM17_46 net54 vb4 vss sub sg13_lv_nmos w=1u l=1u m=1
XT1010 vss sub ptap1 A=4e-12 P=8e-6
XM17_47 net54 vb4 vss sub sg13_lv_nmos w=1u l=1u m=1
XT1011 vss sub ptap1 A=4e-12 P=8e-6
XM17_48 net54 vb4 vss sub sg13_lv_nmos w=1u l=1u m=1
XT1012 vss sub ptap1 A=4e-12 P=8e-6
XM17_49 net54 vb4 vss sub sg13_lv_nmos w=1u l=1u m=1
XT1013 vss sub ptap1 A=4e-12 P=8e-6
XM17_50 net54 vb4 vss sub sg13_lv_nmos w=1u l=1u m=1
XT1014 vss sub ptap1 A=4e-12 P=8e-6
XM17_51 net54 vb4 vss sub sg13_lv_nmos w=1u l=1u m=1
XT1015 vss sub ptap1 A=4e-12 P=8e-6
XM17_52 net54 vb4 vss sub sg13_lv_nmos w=1u l=1u m=1
XT1016 vss sub ptap1 A=4e-12 P=8e-6
XM17_53 net54 vb4 vss sub sg13_lv_nmos w=1u l=1u m=1
XT1017 vss sub ptap1 A=4e-12 P=8e-6
XM17_54 net54 vb4 vss sub sg13_lv_nmos w=1u l=1u m=1
XT1018 vss sub ptap1 A=4e-12 P=8e-6
XM17_55 net54 vb4 vss sub sg13_lv_nmos w=1u l=1u m=1
XT1019 vss sub ptap1 A=4e-12 P=8e-6
XM17_56 net54 vb4 vss sub sg13_lv_nmos w=1u l=1u m=1
XT1020 vss sub ptap1 A=4e-12 P=8e-6
XM17_57 net54 vb4 vss sub sg13_lv_nmos w=1u l=1u m=1
XT1021 vss sub ptap1 A=4e-12 P=8e-6
XM17_58 net54 vb4 vss sub sg13_lv_nmos w=1u l=1u m=1
XT1022 vss sub ptap1 A=4e-12 P=8e-6
XM17_59 net54 vb4 vss sub sg13_lv_nmos w=1u l=1u m=1
XT1023 vss sub ptap1 A=4e-12 P=8e-6
XM17_60 net54 vb4 vss sub sg13_lv_nmos w=1u l=1u m=1
XT1024 vss sub ptap1 A=4e-12 P=8e-6
XM17_61 net54 vb4 vss sub sg13_lv_nmos w=1u l=1u m=1
XT1025 vss sub ptap1 A=4e-12 P=8e-6
XM17_62 net54 vb4 vss sub sg13_lv_nmos w=1u l=1u m=1
XT1026 vss sub ptap1 A=4e-12 P=8e-6
XM17_63 net54 vb4 vss sub sg13_lv_nmos w=1u l=1u m=1
XT1027 vss sub ptap1 A=4e-12 P=8e-6
XM17_64 net54 vb4 vss sub sg13_lv_nmos w=1u l=1u m=1
XT1028 vss sub ptap1 A=4e-12 P=8e-6
XM17_65 net54 vb4 vss sub sg13_lv_nmos w=1u l=1u m=1
XT1029 vss sub ptap1 A=4e-12 P=8e-6
XM17_66 net54 vb4 vss sub sg13_lv_nmos w=1u l=1u m=1
XT1030 vss sub ptap1 A=4e-12 P=8e-6
XM17_67 net54 vb4 vss sub sg13_lv_nmos w=1u l=1u m=1
XT1031 vss sub ptap1 A=4e-12 P=8e-6
XM17_68 net54 vb4 vss sub sg13_lv_nmos w=1u l=1u m=1
XT1032 vss sub ptap1 A=4e-12 P=8e-6
XM17_69 net54 vb4 vss sub sg13_lv_nmos w=1u l=1u m=1
XT1033 vss sub ptap1 A=4e-12 P=8e-6
XM17_70 net54 vb4 vss sub sg13_lv_nmos w=1u l=1u m=1
XT1034 vss sub ptap1 A=4e-12 P=8e-6
XM17_71 net54 vb4 vss sub sg13_lv_nmos w=1u l=1u m=1
XT1035 vss sub ptap1 A=4e-12 P=8e-6
XM17_72 net54 vb4 vss sub sg13_lv_nmos w=1u l=1u m=1
XT1036 vss sub ptap1 A=4e-12 P=8e-6
XM17_73 net54 vb4 vss sub sg13_lv_nmos w=1u l=1u m=1
XT1037 vss sub ptap1 A=4e-12 P=8e-6
XM17_74 net54 vb4 vss sub sg13_lv_nmos w=1u l=1u m=1
XT1038 vss sub ptap1 A=4e-12 P=8e-6
XM17_75 net54 vb4 vss sub sg13_lv_nmos w=1u l=1u m=1
XT1039 vss sub ptap1 A=4e-12 P=8e-6
XM17_76 net54 vb4 vss sub sg13_lv_nmos w=1u l=1u m=1
XT1040 vss sub ptap1 A=4e-12 P=8e-6
XM17_77 net54 vb4 vss sub sg13_lv_nmos w=1u l=1u m=1
XT1041 vss sub ptap1 A=4e-12 P=8e-6
XM17_78 net54 vb4 vss sub sg13_lv_nmos w=1u l=1u m=1
XT1042 vss sub ptap1 A=4e-12 P=8e-6
XM17_79 net54 vb4 vss sub sg13_lv_nmos w=1u l=1u m=1
XT1043 vss sub ptap1 A=4e-12 P=8e-6
XM18_0 net56 vb4 vss sub sg13_lv_nmos w=1u l=1u m=1
XT1044 vss sub ptap1 A=4e-12 P=8e-6
XM18_1 net56 vb4 vss sub sg13_lv_nmos w=1u l=1u m=1
XT1045 vss sub ptap1 A=4e-12 P=8e-6
XM18_2 net56 vb4 vss sub sg13_lv_nmos w=1u l=1u m=1
XT1046 vss sub ptap1 A=4e-12 P=8e-6
XM18_3 net56 vb4 vss sub sg13_lv_nmos w=1u l=1u m=1
XT1047 vss sub ptap1 A=4e-12 P=8e-6
XM18_4 net56 vb4 vss sub sg13_lv_nmos w=1u l=1u m=1
XT1048 vss sub ptap1 A=4e-12 P=8e-6
XM18_5 net56 vb4 vss sub sg13_lv_nmos w=1u l=1u m=1
XT1049 vss sub ptap1 A=4e-12 P=8e-6
XM18_6 net56 vb4 vss sub sg13_lv_nmos w=1u l=1u m=1
XT1050 vss sub ptap1 A=4e-12 P=8e-6
XM18_7 net56 vb4 vss sub sg13_lv_nmos w=1u l=1u m=1
XT1051 vss sub ptap1 A=4e-12 P=8e-6
XM18_8 net56 vb4 vss sub sg13_lv_nmos w=1u l=1u m=1
XT1052 vss sub ptap1 A=4e-12 P=8e-6
XM18_9 net56 vb4 vss sub sg13_lv_nmos w=1u l=1u m=1
XT1053 vss sub ptap1 A=4e-12 P=8e-6
XM18_10 net56 vb4 vss sub sg13_lv_nmos w=1u l=1u m=1
XT1054 vss sub ptap1 A=4e-12 P=8e-6
XM18_11 net56 vb4 vss sub sg13_lv_nmos w=1u l=1u m=1
XT1055 vss sub ptap1 A=4e-12 P=8e-6
XM18_12 net56 vb4 vss sub sg13_lv_nmos w=1u l=1u m=1
XT1056 vss sub ptap1 A=4e-12 P=8e-6
XM18_13 net56 vb4 vss sub sg13_lv_nmos w=1u l=1u m=1
XT1057 vss sub ptap1 A=4e-12 P=8e-6
XM18_14 net56 vb4 vss sub sg13_lv_nmos w=1u l=1u m=1
XT1058 vss sub ptap1 A=4e-12 P=8e-6
XM18_15 net56 vb4 vss sub sg13_lv_nmos w=1u l=1u m=1
XT1059 vss sub ptap1 A=4e-12 P=8e-6
XM18_16 net56 vb4 vss sub sg13_lv_nmos w=1u l=1u m=1
XT1060 vss sub ptap1 A=4e-12 P=8e-6
XM18_17 net56 vb4 vss sub sg13_lv_nmos w=1u l=1u m=1
XT1061 vss sub ptap1 A=4e-12 P=8e-6
XM18_18 net56 vb4 vss sub sg13_lv_nmos w=1u l=1u m=1
XT1062 vss sub ptap1 A=4e-12 P=8e-6
XM18_19 net56 vb4 vss sub sg13_lv_nmos w=1u l=1u m=1
XT1063 vss sub ptap1 A=4e-12 P=8e-6
XM18_20 net56 vb4 vss sub sg13_lv_nmos w=1u l=1u m=1
XT1064 vss sub ptap1 A=4e-12 P=8e-6
XM18_21 net56 vb4 vss sub sg13_lv_nmos w=1u l=1u m=1
XT1065 vss sub ptap1 A=4e-12 P=8e-6
XM18_22 net56 vb4 vss sub sg13_lv_nmos w=1u l=1u m=1
XT1066 vss sub ptap1 A=4e-12 P=8e-6
XM18_23 net56 vb4 vss sub sg13_lv_nmos w=1u l=1u m=1
XT1067 vss sub ptap1 A=4e-12 P=8e-6
XM18_24 net56 vb4 vss sub sg13_lv_nmos w=1u l=1u m=1
XT1068 vss sub ptap1 A=4e-12 P=8e-6
XM18_25 net56 vb4 vss sub sg13_lv_nmos w=1u l=1u m=1
XT1069 vss sub ptap1 A=4e-12 P=8e-6
XM18_26 net56 vb4 vss sub sg13_lv_nmos w=1u l=1u m=1
XT1070 vss sub ptap1 A=4e-12 P=8e-6
XM18_27 net56 vb4 vss sub sg13_lv_nmos w=1u l=1u m=1
XT1071 vss sub ptap1 A=4e-12 P=8e-6
XM18_28 net56 vb4 vss sub sg13_lv_nmos w=1u l=1u m=1
XT1072 vss sub ptap1 A=4e-12 P=8e-6
XM18_29 net56 vb4 vss sub sg13_lv_nmos w=1u l=1u m=1
XT1073 vss sub ptap1 A=4e-12 P=8e-6
XM18_30 net56 vb4 vss sub sg13_lv_nmos w=1u l=1u m=1
XT1074 vss sub ptap1 A=4e-12 P=8e-6
XM18_31 net56 vb4 vss sub sg13_lv_nmos w=1u l=1u m=1
XT1075 vss sub ptap1 A=4e-12 P=8e-6
XM18_32 net56 vb4 vss sub sg13_lv_nmos w=1u l=1u m=1
XT1076 vss sub ptap1 A=4e-12 P=8e-6
XM18_33 net56 vb4 vss sub sg13_lv_nmos w=1u l=1u m=1
XT1077 vss sub ptap1 A=4e-12 P=8e-6
XM18_34 net56 vb4 vss sub sg13_lv_nmos w=1u l=1u m=1
XT1078 vss sub ptap1 A=4e-12 P=8e-6
XM18_35 net56 vb4 vss sub sg13_lv_nmos w=1u l=1u m=1
XT1079 vss sub ptap1 A=4e-12 P=8e-6
XM18_36 net56 vb4 vss sub sg13_lv_nmos w=1u l=1u m=1
XT1080 vss sub ptap1 A=4e-12 P=8e-6
XM18_37 net56 vb4 vss sub sg13_lv_nmos w=1u l=1u m=1
XT1081 vss sub ptap1 A=4e-12 P=8e-6
XM18_38 net56 vb4 vss sub sg13_lv_nmos w=1u l=1u m=1
XT1082 vss sub ptap1 A=4e-12 P=8e-6
XM18_39 net56 vb4 vss sub sg13_lv_nmos w=1u l=1u m=1
XT1083 vss sub ptap1 A=4e-12 P=8e-6
XM18_40 net56 vb4 vss sub sg13_lv_nmos w=1u l=1u m=1
XT1084 vss sub ptap1 A=4e-12 P=8e-6
XM18_41 net56 vb4 vss sub sg13_lv_nmos w=1u l=1u m=1
XT1085 vss sub ptap1 A=4e-12 P=8e-6
XM18_42 net56 vb4 vss sub sg13_lv_nmos w=1u l=1u m=1
XT1086 vss sub ptap1 A=4e-12 P=8e-6
XM18_43 net56 vb4 vss sub sg13_lv_nmos w=1u l=1u m=1
XT1087 vss sub ptap1 A=4e-12 P=8e-6
XM18_44 net56 vb4 vss sub sg13_lv_nmos w=1u l=1u m=1
XT1088 vss sub ptap1 A=4e-12 P=8e-6
XM18_45 net56 vb4 vss sub sg13_lv_nmos w=1u l=1u m=1
XT1089 vss sub ptap1 A=4e-12 P=8e-6
XM18_46 net56 vb4 vss sub sg13_lv_nmos w=1u l=1u m=1
XT1090 vss sub ptap1 A=4e-12 P=8e-6
XM18_47 net56 vb4 vss sub sg13_lv_nmos w=1u l=1u m=1
XT1091 vss sub ptap1 A=4e-12 P=8e-6
XM18_48 net56 vb4 vss sub sg13_lv_nmos w=1u l=1u m=1
XT1092 vss sub ptap1 A=4e-12 P=8e-6
XM18_49 net56 vb4 vss sub sg13_lv_nmos w=1u l=1u m=1
XT1093 vss sub ptap1 A=4e-12 P=8e-6
XM18_50 net56 vb4 vss sub sg13_lv_nmos w=1u l=1u m=1
XT1094 vss sub ptap1 A=4e-12 P=8e-6
XM18_51 net56 vb4 vss sub sg13_lv_nmos w=1u l=1u m=1
XT1095 vss sub ptap1 A=4e-12 P=8e-6
XM18_52 net56 vb4 vss sub sg13_lv_nmos w=1u l=1u m=1
XT1096 vss sub ptap1 A=4e-12 P=8e-6
XM18_53 net56 vb4 vss sub sg13_lv_nmos w=1u l=1u m=1
XT1097 vss sub ptap1 A=4e-12 P=8e-6
XM18_54 net56 vb4 vss sub sg13_lv_nmos w=1u l=1u m=1
XT1098 vss sub ptap1 A=4e-12 P=8e-6
XM18_55 net56 vb4 vss sub sg13_lv_nmos w=1u l=1u m=1
XT1099 vss sub ptap1 A=4e-12 P=8e-6
XM18_56 net56 vb4 vss sub sg13_lv_nmos w=1u l=1u m=1
XT1100 vss sub ptap1 A=4e-12 P=8e-6
XM18_57 net56 vb4 vss sub sg13_lv_nmos w=1u l=1u m=1
XT1101 vss sub ptap1 A=4e-12 P=8e-6
XM18_58 net56 vb4 vss sub sg13_lv_nmos w=1u l=1u m=1
XT1102 vss sub ptap1 A=4e-12 P=8e-6
XM18_59 net56 vb4 vss sub sg13_lv_nmos w=1u l=1u m=1
XT1103 vss sub ptap1 A=4e-12 P=8e-6
XM18_60 net56 vb4 vss sub sg13_lv_nmos w=1u l=1u m=1
XT1104 vss sub ptap1 A=4e-12 P=8e-6
XM18_61 net56 vb4 vss sub sg13_lv_nmos w=1u l=1u m=1
XT1105 vss sub ptap1 A=4e-12 P=8e-6
XM18_62 net56 vb4 vss sub sg13_lv_nmos w=1u l=1u m=1
XT1106 vss sub ptap1 A=4e-12 P=8e-6
XM18_63 net56 vb4 vss sub sg13_lv_nmos w=1u l=1u m=1
XT1107 vss sub ptap1 A=4e-12 P=8e-6
XM18_64 net56 vb4 vss sub sg13_lv_nmos w=1u l=1u m=1
XT1108 vss sub ptap1 A=4e-12 P=8e-6
XM18_65 net56 vb4 vss sub sg13_lv_nmos w=1u l=1u m=1
XT1109 vss sub ptap1 A=4e-12 P=8e-6
XM18_66 net56 vb4 vss sub sg13_lv_nmos w=1u l=1u m=1
XT1110 vss sub ptap1 A=4e-12 P=8e-6
XM18_67 net56 vb4 vss sub sg13_lv_nmos w=1u l=1u m=1
XT1111 vss sub ptap1 A=4e-12 P=8e-6
XM18_68 net56 vb4 vss sub sg13_lv_nmos w=1u l=1u m=1
XT1112 vss sub ptap1 A=4e-12 P=8e-6
XM18_69 net56 vb4 vss sub sg13_lv_nmos w=1u l=1u m=1
XT1113 vss sub ptap1 A=4e-12 P=8e-6
XM18_70 net56 vb4 vss sub sg13_lv_nmos w=1u l=1u m=1
XT1114 vss sub ptap1 A=4e-12 P=8e-6
XM18_71 net56 vb4 vss sub sg13_lv_nmos w=1u l=1u m=1
XT1115 vss sub ptap1 A=4e-12 P=8e-6
XM18_72 net56 vb4 vss sub sg13_lv_nmos w=1u l=1u m=1
XT1116 vss sub ptap1 A=4e-12 P=8e-6
XM18_73 net56 vb4 vss sub sg13_lv_nmos w=1u l=1u m=1
XT1117 vss sub ptap1 A=4e-12 P=8e-6
XM18_74 net56 vb4 vss sub sg13_lv_nmos w=1u l=1u m=1
XT1118 vss sub ptap1 A=4e-12 P=8e-6
XM18_75 net56 vb4 vss sub sg13_lv_nmos w=1u l=1u m=1
XT1119 vss sub ptap1 A=4e-12 P=8e-6
XM18_76 net56 vb4 vss sub sg13_lv_nmos w=1u l=1u m=1
XT1120 vss sub ptap1 A=4e-12 P=8e-6
XM18_77 net56 vb4 vss sub sg13_lv_nmos w=1u l=1u m=1
XT1121 vss sub ptap1 A=4e-12 P=8e-6
XM18_78 net56 vb4 vss sub sg13_lv_nmos w=1u l=1u m=1
XT1122 vss sub ptap1 A=4e-12 P=8e-6
XM18_79 net56 vb4 vss sub sg13_lv_nmos w=1u l=1u m=1
XT1123 vss sub ptap1 A=4e-12 P=8e-6
XM19_0 dm_2 vb4 vss sub sg13_lv_nmos w=1u l=1u m=1
XT1124 vss sub ptap1 A=4e-12 P=8e-6
XM19_1 dm_2 vb4 vss sub sg13_lv_nmos w=1u l=1u m=1
XT1125 vss sub ptap1 A=4e-12 P=8e-6
XM19_2 dm_2 vb4 vss sub sg13_lv_nmos w=1u l=1u m=1
XT1126 vss sub ptap1 A=4e-12 P=8e-6
XM19_3 dm_2 vb4 vss sub sg13_lv_nmos w=1u l=1u m=1
XT1127 vss sub ptap1 A=4e-12 P=8e-6
XM19_4 dm_2 vb4 vss sub sg13_lv_nmos w=1u l=1u m=1
XT1128 vss sub ptap1 A=4e-12 P=8e-6
XM19_5 dm_2 vb4 vss sub sg13_lv_nmos w=1u l=1u m=1
XT1129 vss sub ptap1 A=4e-12 P=8e-6
XM19_6 dm_2 vb4 vss sub sg13_lv_nmos w=1u l=1u m=1
XT1130 vss sub ptap1 A=4e-12 P=8e-6
XM19_7 dm_2 vb4 vss sub sg13_lv_nmos w=1u l=1u m=1
XT1131 vss sub ptap1 A=4e-12 P=8e-6
XM19_8 dm_2 vb4 vss sub sg13_lv_nmos w=1u l=1u m=1
XT1132 vss sub ptap1 A=4e-12 P=8e-6
XM19_9 dm_2 vb4 vss sub sg13_lv_nmos w=1u l=1u m=1
XT1133 vss sub ptap1 A=4e-12 P=8e-6
XM19_10 dm_2 vb4 vss sub sg13_lv_nmos w=1u l=1u m=1
XT1134 vss sub ptap1 A=4e-12 P=8e-6
XM19_11 dm_2 vb4 vss sub sg13_lv_nmos w=1u l=1u m=1
XT1135 vss sub ptap1 A=4e-12 P=8e-6
XM19_12 dm_2 vb4 vss sub sg13_lv_nmos w=1u l=1u m=1
XT1136 vss sub ptap1 A=4e-12 P=8e-6
XM19_13 dm_2 vb4 vss sub sg13_lv_nmos w=1u l=1u m=1
XT1137 vss sub ptap1 A=4e-12 P=8e-6
XM19_14 dm_2 vb4 vss sub sg13_lv_nmos w=1u l=1u m=1
XT1138 vss sub ptap1 A=4e-12 P=8e-6
XM19_15 dm_2 vb4 vss sub sg13_lv_nmos w=1u l=1u m=1
XT1139 vss sub ptap1 A=4e-12 P=8e-6
XM19_16 dm_2 vb4 vss sub sg13_lv_nmos w=1u l=1u m=1
XT1140 vss sub ptap1 A=4e-12 P=8e-6
XM19_17 dm_2 vb4 vss sub sg13_lv_nmos w=1u l=1u m=1
XT1141 vss sub ptap1 A=4e-12 P=8e-6
XM19_18 dm_2 vb4 vss sub sg13_lv_nmos w=1u l=1u m=1
XT1142 vss sub ptap1 A=4e-12 P=8e-6
XM19_19 dm_2 vb4 vss sub sg13_lv_nmos w=1u l=1u m=1
XT1143 vss sub ptap1 A=4e-12 P=8e-6
XM19_20 dm_2 vb4 vss sub sg13_lv_nmos w=1u l=1u m=1
XT1144 vss sub ptap1 A=4e-12 P=8e-6
XM19_21 dm_2 vb4 vss sub sg13_lv_nmos w=1u l=1u m=1
XT1145 vss sub ptap1 A=4e-12 P=8e-6
XM19_22 dm_2 vb4 vss sub sg13_lv_nmos w=1u l=1u m=1
XT1146 vss sub ptap1 A=4e-12 P=8e-6
XM19_23 dm_2 vb4 vss sub sg13_lv_nmos w=1u l=1u m=1
XT1147 vss sub ptap1 A=4e-12 P=8e-6
XM19_24 dm_2 vb4 vss sub sg13_lv_nmos w=1u l=1u m=1
XT1148 vss sub ptap1 A=4e-12 P=8e-6
XM19_25 dm_2 vb4 vss sub sg13_lv_nmos w=1u l=1u m=1
XT1149 vss sub ptap1 A=4e-12 P=8e-6
XM19_26 dm_2 vb4 vss sub sg13_lv_nmos w=1u l=1u m=1
XT1150 vss sub ptap1 A=4e-12 P=8e-6
XM19_27 dm_2 vb4 vss sub sg13_lv_nmos w=1u l=1u m=1
XT1151 vss sub ptap1 A=4e-12 P=8e-6
XM19_28 dm_2 vb4 vss sub sg13_lv_nmos w=1u l=1u m=1
XT1152 vss sub ptap1 A=4e-12 P=8e-6
XM19_29 dm_2 vb4 vss sub sg13_lv_nmos w=1u l=1u m=1
XT1153 vss sub ptap1 A=4e-12 P=8e-6
XM19_30 dm_2 vb4 vss sub sg13_lv_nmos w=1u l=1u m=1
XT1154 vss sub ptap1 A=4e-12 P=8e-6
XM19_31 dm_2 vb4 vss sub sg13_lv_nmos w=1u l=1u m=1
XT1155 vss sub ptap1 A=4e-12 P=8e-6
XM19_32 dm_2 vb4 vss sub sg13_lv_nmos w=1u l=1u m=1
XT1156 vss sub ptap1 A=4e-12 P=8e-6
XM19_33 dm_2 vb4 vss sub sg13_lv_nmos w=1u l=1u m=1
XT1157 vss sub ptap1 A=4e-12 P=8e-6
XM19_34 dm_2 vb4 vss sub sg13_lv_nmos w=1u l=1u m=1
XT1158 vss sub ptap1 A=4e-12 P=8e-6
XM19_35 dm_2 vb4 vss sub sg13_lv_nmos w=1u l=1u m=1
XT1159 vss sub ptap1 A=4e-12 P=8e-6
XM19_36 dm_2 vb4 vss sub sg13_lv_nmos w=1u l=1u m=1
XT1160 vss sub ptap1 A=4e-12 P=8e-6
XM19_37 dm_2 vb4 vss sub sg13_lv_nmos w=1u l=1u m=1
XT1161 vss sub ptap1 A=4e-12 P=8e-6
XM19_38 dm_2 vb4 vss sub sg13_lv_nmos w=1u l=1u m=1
XT1162 vss sub ptap1 A=4e-12 P=8e-6
XM19_39 dm_2 vb4 vss sub sg13_lv_nmos w=1u l=1u m=1
XT1163 vss sub ptap1 A=4e-12 P=8e-6
XM19_40 dm_2 vb4 vss sub sg13_lv_nmos w=1u l=1u m=1
XT1164 vss sub ptap1 A=4e-12 P=8e-6
XM19_41 dm_2 vb4 vss sub sg13_lv_nmos w=1u l=1u m=1
XT1165 vss sub ptap1 A=4e-12 P=8e-6
XM19_42 dm_2 vb4 vss sub sg13_lv_nmos w=1u l=1u m=1
XT1166 vss sub ptap1 A=4e-12 P=8e-6
XM19_43 dm_2 vb4 vss sub sg13_lv_nmos w=1u l=1u m=1
XT1167 vss sub ptap1 A=4e-12 P=8e-6
XM19_44 dm_2 vb4 vss sub sg13_lv_nmos w=1u l=1u m=1
XT1168 vss sub ptap1 A=4e-12 P=8e-6
XM19_45 dm_2 vb4 vss sub sg13_lv_nmos w=1u l=1u m=1
XT1169 vss sub ptap1 A=4e-12 P=8e-6
XM19_46 dm_2 vb4 vss sub sg13_lv_nmos w=1u l=1u m=1
XT1170 vss sub ptap1 A=4e-12 P=8e-6
XM19_47 dm_2 vb4 vss sub sg13_lv_nmos w=1u l=1u m=1
XT1171 vss sub ptap1 A=4e-12 P=8e-6
XM19_48 dm_2 vb4 vss sub sg13_lv_nmos w=1u l=1u m=1
XT1172 vss sub ptap1 A=4e-12 P=8e-6
XM19_49 dm_2 vb4 vss sub sg13_lv_nmos w=1u l=1u m=1
XT1173 vss sub ptap1 A=4e-12 P=8e-6
XM19_50 dm_2 vb4 vss sub sg13_lv_nmos w=1u l=1u m=1
XT1174 vss sub ptap1 A=4e-12 P=8e-6
XM19_51 dm_2 vb4 vss sub sg13_lv_nmos w=1u l=1u m=1
XT1175 vss sub ptap1 A=4e-12 P=8e-6
XM19_52 dm_2 vb4 vss sub sg13_lv_nmos w=1u l=1u m=1
XT1176 vss sub ptap1 A=4e-12 P=8e-6
XM19_53 dm_2 vb4 vss sub sg13_lv_nmos w=1u l=1u m=1
XT1177 vss sub ptap1 A=4e-12 P=8e-6
XM19_54 dm_2 vb4 vss sub sg13_lv_nmos w=1u l=1u m=1
XT1178 vss sub ptap1 A=4e-12 P=8e-6
XM19_55 dm_2 vb4 vss sub sg13_lv_nmos w=1u l=1u m=1
XT1179 vss sub ptap1 A=4e-12 P=8e-6
XM19_56 dm_2 vb4 vss sub sg13_lv_nmos w=1u l=1u m=1
XT1180 vss sub ptap1 A=4e-12 P=8e-6
XM19_57 dm_2 vb4 vss sub sg13_lv_nmos w=1u l=1u m=1
XT1181 vss sub ptap1 A=4e-12 P=8e-6
XM19_58 dm_2 vb4 vss sub sg13_lv_nmos w=1u l=1u m=1
XT1182 vss sub ptap1 A=4e-12 P=8e-6
XM19_59 dm_2 vb4 vss sub sg13_lv_nmos w=1u l=1u m=1
XT1183 vss sub ptap1 A=4e-12 P=8e-6
XM19_60 dm_2 vb4 vss sub sg13_lv_nmos w=1u l=1u m=1
XT1184 vss sub ptap1 A=4e-12 P=8e-6
XM19_61 dm_2 vb4 vss sub sg13_lv_nmos w=1u l=1u m=1
XT1185 vss sub ptap1 A=4e-12 P=8e-6
XM19_62 dm_2 vb4 vss sub sg13_lv_nmos w=1u l=1u m=1
XT1186 vss sub ptap1 A=4e-12 P=8e-6
XM19_63 dm_2 vb4 vss sub sg13_lv_nmos w=1u l=1u m=1
XT1187 vss sub ptap1 A=4e-12 P=8e-6
XM19_64 dm_2 vb4 vss sub sg13_lv_nmos w=1u l=1u m=1
XT1188 vss sub ptap1 A=4e-12 P=8e-6
XM19_65 dm_2 vb4 vss sub sg13_lv_nmos w=1u l=1u m=1
XT1189 vss sub ptap1 A=4e-12 P=8e-6
XM19_66 dm_2 vb4 vss sub sg13_lv_nmos w=1u l=1u m=1
XT1190 vss sub ptap1 A=4e-12 P=8e-6
XM19_67 dm_2 vb4 vss sub sg13_lv_nmos w=1u l=1u m=1
XT1191 vss sub ptap1 A=4e-12 P=8e-6
XM19_68 dm_2 vb4 vss sub sg13_lv_nmos w=1u l=1u m=1
XT1192 vss sub ptap1 A=4e-12 P=8e-6
XM19_69 dm_2 vb4 vss sub sg13_lv_nmos w=1u l=1u m=1
XT1193 vss sub ptap1 A=4e-12 P=8e-6
XM19_70 dm_2 vb4 vss sub sg13_lv_nmos w=1u l=1u m=1
XT1194 vss sub ptap1 A=4e-12 P=8e-6
XM19_71 dm_2 vb4 vss sub sg13_lv_nmos w=1u l=1u m=1
XT1195 vss sub ptap1 A=4e-12 P=8e-6
XM19_72 dm_2 vb4 vss sub sg13_lv_nmos w=1u l=1u m=1
XT1196 vss sub ptap1 A=4e-12 P=8e-6
XM19_73 dm_2 vb4 vss sub sg13_lv_nmos w=1u l=1u m=1
XT1197 vss sub ptap1 A=4e-12 P=8e-6
XM19_74 dm_2 vb4 vss sub sg13_lv_nmos w=1u l=1u m=1
XT1198 vss sub ptap1 A=4e-12 P=8e-6
XM19_75 dm_2 vb4 vss sub sg13_lv_nmos w=1u l=1u m=1
XT1199 vss sub ptap1 A=4e-12 P=8e-6
XM19_76 dm_2 vb4 vss sub sg13_lv_nmos w=1u l=1u m=1
XT1200 vss sub ptap1 A=4e-12 P=8e-6
XM19_77 dm_2 vb4 vss sub sg13_lv_nmos w=1u l=1u m=1
XT1201 vss sub ptap1 A=4e-12 P=8e-6
XM19_78 dm_2 vb4 vss sub sg13_lv_nmos w=1u l=1u m=1
XT1202 vss sub ptap1 A=4e-12 P=8e-6
XM19_79 dm_2 vb4 vss sub sg13_lv_nmos w=1u l=1u m=1
XT1203 vss sub ptap1 A=4e-12 P=8e-6
XM19_80 dm_2 vb4 vss sub sg13_lv_nmos w=1u l=1u m=1
XT1204 vss sub ptap1 A=4e-12 P=8e-6
XM19_81 dm_2 vb4 vss sub sg13_lv_nmos w=1u l=1u m=1
XT1205 vss sub ptap1 A=4e-12 P=8e-6
XM19_82 dm_2 vb4 vss sub sg13_lv_nmos w=1u l=1u m=1
XT1206 vss sub ptap1 A=4e-12 P=8e-6
XM19_83 dm_2 vb4 vss sub sg13_lv_nmos w=1u l=1u m=1
XT1207 vss sub ptap1 A=4e-12 P=8e-6
XM19_84 dm_2 vb4 vss sub sg13_lv_nmos w=1u l=1u m=1
XT1208 vss sub ptap1 A=4e-12 P=8e-6
XM19_85 dm_2 vb4 vss sub sg13_lv_nmos w=1u l=1u m=1
XT1209 vss sub ptap1 A=4e-12 P=8e-6
XM19_86 dm_2 vb4 vss sub sg13_lv_nmos w=1u l=1u m=1
XT1210 vss sub ptap1 A=4e-12 P=8e-6
XM19_87 dm_2 vb4 vss sub sg13_lv_nmos w=1u l=1u m=1
XT1211 vss sub ptap1 A=4e-12 P=8e-6
XM19_88 dm_2 vb4 vss sub sg13_lv_nmos w=1u l=1u m=1
XT1212 vss sub ptap1 A=4e-12 P=8e-6
XM19_89 dm_2 vb4 vss sub sg13_lv_nmos w=1u l=1u m=1
XT1213 vss sub ptap1 A=4e-12 P=8e-6
XM19_90 dm_2 vb4 vss sub sg13_lv_nmos w=1u l=1u m=1
XT1214 vss sub ptap1 A=4e-12 P=8e-6
XM19_91 dm_2 vb4 vss sub sg13_lv_nmos w=1u l=1u m=1
XT1215 vss sub ptap1 A=4e-12 P=8e-6
XM19_92 dm_2 vb4 vss sub sg13_lv_nmos w=1u l=1u m=1
XT1216 vss sub ptap1 A=4e-12 P=8e-6
XM19_93 dm_2 vb4 vss sub sg13_lv_nmos w=1u l=1u m=1
XT1217 vss sub ptap1 A=4e-12 P=8e-6
XM19_94 dm_2 vb4 vss sub sg13_lv_nmos w=1u l=1u m=1
XT1218 vss sub ptap1 A=4e-12 P=8e-6
XM19_95 dm_2 vb4 vss sub sg13_lv_nmos w=1u l=1u m=1
XT1219 vss sub ptap1 A=4e-12 P=8e-6
XM19_96 dm_2 vb4 vss sub sg13_lv_nmos w=1u l=1u m=1
XT1220 vss sub ptap1 A=4e-12 P=8e-6
XM19_97 dm_2 vb4 vss sub sg13_lv_nmos w=1u l=1u m=1
XT1221 vss sub ptap1 A=4e-12 P=8e-6
XM19_98 dm_2 vb4 vss sub sg13_lv_nmos w=1u l=1u m=1
XT1222 vss sub ptap1 A=4e-12 P=8e-6
XM19_99 dm_2 vb4 vss sub sg13_lv_nmos w=1u l=1u m=1
XT1223 vss sub ptap1 A=4e-12 P=8e-6
XM19_100 dm_2 vb4 vss sub sg13_lv_nmos w=1u l=1u m=1
XT1224 vss sub ptap1 A=4e-12 P=8e-6
XM19_101 dm_2 vb4 vss sub sg13_lv_nmos w=1u l=1u m=1
XT1225 vss sub ptap1 A=4e-12 P=8e-6
XM19_102 dm_2 vb4 vss sub sg13_lv_nmos w=1u l=1u m=1
XT1226 vss sub ptap1 A=4e-12 P=8e-6
XM19_103 dm_2 vb4 vss sub sg13_lv_nmos w=1u l=1u m=1
XT1227 vss sub ptap1 A=4e-12 P=8e-6
XM19_104 dm_2 vb4 vss sub sg13_lv_nmos w=1u l=1u m=1
XT1228 vss sub ptap1 A=4e-12 P=8e-6
XM19_105 dm_2 vb4 vss sub sg13_lv_nmos w=1u l=1u m=1
XT1229 vss sub ptap1 A=4e-12 P=8e-6
XM19_106 dm_2 vb4 vss sub sg13_lv_nmos w=1u l=1u m=1
XT1230 vss sub ptap1 A=4e-12 P=8e-6
XM19_107 dm_2 vb4 vss sub sg13_lv_nmos w=1u l=1u m=1
XT1231 vss sub ptap1 A=4e-12 P=8e-6
XM19_108 dm_2 vb4 vss sub sg13_lv_nmos w=1u l=1u m=1
XT1232 vss sub ptap1 A=4e-12 P=8e-6
XM19_109 dm_2 vb4 vss sub sg13_lv_nmos w=1u l=1u m=1
XT1233 vss sub ptap1 A=4e-12 P=8e-6
XM19_110 dm_2 vb4 vss sub sg13_lv_nmos w=1u l=1u m=1
XT1234 vss sub ptap1 A=4e-12 P=8e-6
XM19_111 dm_2 vb4 vss sub sg13_lv_nmos w=1u l=1u m=1
XT1235 vss sub ptap1 A=4e-12 P=8e-6
XM19_112 dm_2 vb4 vss sub sg13_lv_nmos w=1u l=1u m=1
XT1236 vss sub ptap1 A=4e-12 P=8e-6
XM19_113 dm_2 vb4 vss sub sg13_lv_nmos w=1u l=1u m=1
XT1237 vss sub ptap1 A=4e-12 P=8e-6
XM19_114 dm_2 vb4 vss sub sg13_lv_nmos w=1u l=1u m=1
XT1238 vss sub ptap1 A=4e-12 P=8e-6
XM19_115 dm_2 vb4 vss sub sg13_lv_nmos w=1u l=1u m=1
XT1239 vss sub ptap1 A=4e-12 P=8e-6
XM19_116 dm_2 vb4 vss sub sg13_lv_nmos w=1u l=1u m=1
XT1240 vss sub ptap1 A=4e-12 P=8e-6
XM19_117 dm_2 vb4 vss sub sg13_lv_nmos w=1u l=1u m=1
XT1241 vss sub ptap1 A=4e-12 P=8e-6
XM19_118 dm_2 vb4 vss sub sg13_lv_nmos w=1u l=1u m=1
XT1242 vss sub ptap1 A=4e-12 P=8e-6
XM19_119 dm_2 vb4 vss sub sg13_lv_nmos w=1u l=1u m=1
XT1243 vss sub ptap1 A=4e-12 P=8e-6
XM19_120 dm_2 vb4 vss sub sg13_lv_nmos w=1u l=1u m=1
XT1244 vss sub ptap1 A=4e-12 P=8e-6
XM19_121 dm_2 vb4 vss sub sg13_lv_nmos w=1u l=1u m=1
XT1245 vss sub ptap1 A=4e-12 P=8e-6
XM19_122 dm_2 vb4 vss sub sg13_lv_nmos w=1u l=1u m=1
XT1246 vss sub ptap1 A=4e-12 P=8e-6
XM19_123 dm_2 vb4 vss sub sg13_lv_nmos w=1u l=1u m=1
XT1247 vss sub ptap1 A=4e-12 P=8e-6
XM19_124 dm_2 vb4 vss sub sg13_lv_nmos w=1u l=1u m=1
XT1248 vss sub ptap1 A=4e-12 P=8e-6
XM19_125 dm_2 vb4 vss sub sg13_lv_nmos w=1u l=1u m=1
XT1249 vss sub ptap1 A=4e-12 P=8e-6
XM19_126 dm_2 vb4 vss sub sg13_lv_nmos w=1u l=1u m=1
XT1250 vss sub ptap1 A=4e-12 P=8e-6
XM19_127 dm_2 vb4 vss sub sg13_lv_nmos w=1u l=1u m=1
XT1251 vss sub ptap1 A=4e-12 P=8e-6
XM19_128 dm_2 vb4 vss sub sg13_lv_nmos w=1u l=1u m=1
XT1252 vss sub ptap1 A=4e-12 P=8e-6
XM19_129 dm_2 vb4 vss sub sg13_lv_nmos w=1u l=1u m=1
XT1253 vss sub ptap1 A=4e-12 P=8e-6
XM19_130 dm_2 vb4 vss sub sg13_lv_nmos w=1u l=1u m=1
XT1254 vss sub ptap1 A=4e-12 P=8e-6
XM19_131 dm_2 vb4 vss sub sg13_lv_nmos w=1u l=1u m=1
XT1255 vss sub ptap1 A=4e-12 P=8e-6
XM19_132 dm_2 vb4 vss sub sg13_lv_nmos w=1u l=1u m=1
XT1256 vss sub ptap1 A=4e-12 P=8e-6
XM19_133 dm_2 vb4 vss sub sg13_lv_nmos w=1u l=1u m=1
XT1257 vss sub ptap1 A=4e-12 P=8e-6
XM19_134 dm_2 vb4 vss sub sg13_lv_nmos w=1u l=1u m=1
XT1258 vss sub ptap1 A=4e-12 P=8e-6
XM19_135 dm_2 vb4 vss sub sg13_lv_nmos w=1u l=1u m=1
XT1259 vss sub ptap1 A=4e-12 P=8e-6
XM19_136 dm_2 vb4 vss sub sg13_lv_nmos w=1u l=1u m=1
XT1260 vss sub ptap1 A=4e-12 P=8e-6
XM19_137 dm_2 vb4 vss sub sg13_lv_nmos w=1u l=1u m=1
XT1261 vss sub ptap1 A=4e-12 P=8e-6
XM19_138 dm_2 vb4 vss sub sg13_lv_nmos w=1u l=1u m=1
XT1262 vss sub ptap1 A=4e-12 P=8e-6
XM19_139 dm_2 vb4 vss sub sg13_lv_nmos w=1u l=1u m=1
XT1263 vss sub ptap1 A=4e-12 P=8e-6
XM19_140 dm_2 vb4 vss sub sg13_lv_nmos w=1u l=1u m=1
XT1264 vss sub ptap1 A=4e-12 P=8e-6
XM19_141 dm_2 vb4 vss sub sg13_lv_nmos w=1u l=1u m=1
XT1265 vss sub ptap1 A=4e-12 P=8e-6
XM19_142 dm_2 vb4 vss sub sg13_lv_nmos w=1u l=1u m=1
XT1266 vss sub ptap1 A=4e-12 P=8e-6
XM19_143 dm_2 vb4 vss sub sg13_lv_nmos w=1u l=1u m=1
XT1267 vss sub ptap1 A=4e-12 P=8e-6
XM19_144 dm_2 vb4 vss sub sg13_lv_nmos w=1u l=1u m=1
XT1268 vss sub ptap1 A=4e-12 P=8e-6
XM19_145 dm_2 vb4 vss sub sg13_lv_nmos w=1u l=1u m=1
XT1269 vss sub ptap1 A=4e-12 P=8e-6
XM19_146 dm_2 vb4 vss sub sg13_lv_nmos w=1u l=1u m=1
XT1270 vss sub ptap1 A=4e-12 P=8e-6
XM19_147 dm_2 vb4 vss sub sg13_lv_nmos w=1u l=1u m=1
XT1271 vss sub ptap1 A=4e-12 P=8e-6
XM19_148 dm_2 vb4 vss sub sg13_lv_nmos w=1u l=1u m=1
XT1272 vss sub ptap1 A=4e-12 P=8e-6
XM19_149 dm_2 vb4 vss sub sg13_lv_nmos w=1u l=1u m=1
XT1273 vss sub ptap1 A=4e-12 P=8e-6
XM19_150 dm_2 vb4 vss sub sg13_lv_nmos w=1u l=1u m=1
XT1274 vss sub ptap1 A=4e-12 P=8e-6
XM19_151 dm_2 vb4 vss sub sg13_lv_nmos w=1u l=1u m=1
XT1275 vss sub ptap1 A=4e-12 P=8e-6
XM19_152 dm_2 vb4 vss sub sg13_lv_nmos w=1u l=1u m=1
XT1276 vss sub ptap1 A=4e-12 P=8e-6
XM19_153 dm_2 vb4 vss sub sg13_lv_nmos w=1u l=1u m=1
XT1277 vss sub ptap1 A=4e-12 P=8e-6
XM19_154 dm_2 vb4 vss sub sg13_lv_nmos w=1u l=1u m=1
XT1278 vss sub ptap1 A=4e-12 P=8e-6
XM19_155 dm_2 vb4 vss sub sg13_lv_nmos w=1u l=1u m=1
XT1279 vss sub ptap1 A=4e-12 P=8e-6
XM19_156 dm_2 vb4 vss sub sg13_lv_nmos w=1u l=1u m=1
XT1280 vss sub ptap1 A=4e-12 P=8e-6
XM19_157 dm_2 vb4 vss sub sg13_lv_nmos w=1u l=1u m=1
XT1281 vss sub ptap1 A=4e-12 P=8e-6
XM19_158 dm_2 vb4 vss sub sg13_lv_nmos w=1u l=1u m=1
XT1282 vss sub ptap1 A=4e-12 P=8e-6
XM19_159 dm_2 vb4 vss sub sg13_lv_nmos w=1u l=1u m=1
XT1283 vdd well_1283 ntap1 A=4e-12 P=8e-6
XM2_0 dm_1 net1 vdd well_1283 sg13_lv_pmos w=1u l=1u m=1
XT1284 vdd well_1284 ntap1 A=4e-12 P=8e-6
XM2_1 dm_1 net1 vdd well_1284 sg13_lv_pmos w=1u l=1u m=1
XT1285 vdd well_1285 ntap1 A=4e-12 P=8e-6
XM2_2 dm_1 net1 vdd well_1285 sg13_lv_pmos w=1u l=1u m=1
XT1286 vdd well_1286 ntap1 A=4e-12 P=8e-6
XM2_3 dm_1 net1 vdd well_1286 sg13_lv_pmos w=1u l=1u m=1
XT1287 vdd well_1287 ntap1 A=4e-12 P=8e-6
XM2_4 dm_1 net1 vdd well_1287 sg13_lv_pmos w=1u l=1u m=1
XT1288 vdd well_1288 ntap1 A=4e-12 P=8e-6
XM2_5 dm_1 net1 vdd well_1288 sg13_lv_pmos w=1u l=1u m=1
XT1289 vdd well_1289 ntap1 A=4e-12 P=8e-6
XM2_6 dm_1 net1 vdd well_1289 sg13_lv_pmos w=1u l=1u m=1
XT1290 vdd well_1290 ntap1 A=4e-12 P=8e-6
XM2_7 dm_1 net1 vdd well_1290 sg13_lv_pmos w=1u l=1u m=1
XT1291 vdd well_1291 ntap1 A=4e-12 P=8e-6
XM2_8 dm_1 net1 vdd well_1291 sg13_lv_pmos w=1u l=1u m=1
XT1292 vdd well_1292 ntap1 A=4e-12 P=8e-6
XM2_9 dm_1 net1 vdd well_1292 sg13_lv_pmos w=1u l=1u m=1
XT1293 vdd well_1293 ntap1 A=4e-12 P=8e-6
XM2_10 dm_1 net1 vdd well_1293 sg13_lv_pmos w=1u l=1u m=1
XT1294 vdd well_1294 ntap1 A=4e-12 P=8e-6
XM2_11 dm_1 net1 vdd well_1294 sg13_lv_pmos w=1u l=1u m=1
XT1295 vdd well_1295 ntap1 A=4e-12 P=8e-6
XM2_12 dm_1 net1 vdd well_1295 sg13_lv_pmos w=1u l=1u m=1
XT1296 vdd well_1296 ntap1 A=4e-12 P=8e-6
XM2_13 dm_1 net1 vdd well_1296 sg13_lv_pmos w=1u l=1u m=1
XT1297 vdd well_1297 ntap1 A=4e-12 P=8e-6
XM2_14 dm_1 net1 vdd well_1297 sg13_lv_pmos w=1u l=1u m=1
XT1298 vdd well_1298 ntap1 A=4e-12 P=8e-6
XM2_15 dm_1 net1 vdd well_1298 sg13_lv_pmos w=1u l=1u m=1
XT1299 vdd well_1299 ntap1 A=4e-12 P=8e-6
XM2_16 dm_1 net1 vdd well_1299 sg13_lv_pmos w=1u l=1u m=1
XT1300 vdd well_1300 ntap1 A=4e-12 P=8e-6
XM2_17 dm_1 net1 vdd well_1300 sg13_lv_pmos w=1u l=1u m=1
XT1301 vdd well_1301 ntap1 A=4e-12 P=8e-6
XM2_18 dm_1 net1 vdd well_1301 sg13_lv_pmos w=1u l=1u m=1
XT1302 vdd well_1302 ntap1 A=4e-12 P=8e-6
XM2_19 dm_1 net1 vdd well_1302 sg13_lv_pmos w=1u l=1u m=1
XT1303 vdd well_1303 ntap1 A=4e-12 P=8e-6
XM2_20 dm_1 net1 vdd well_1303 sg13_lv_pmos w=1u l=1u m=1
XT1304 vdd well_1304 ntap1 A=4e-12 P=8e-6
XM2_21 dm_1 net1 vdd well_1304 sg13_lv_pmos w=1u l=1u m=1
XT1305 vdd well_1305 ntap1 A=4e-12 P=8e-6
XM2_22 dm_1 net1 vdd well_1305 sg13_lv_pmos w=1u l=1u m=1
XT1306 vdd well_1306 ntap1 A=4e-12 P=8e-6
XM2_23 dm_1 net1 vdd well_1306 sg13_lv_pmos w=1u l=1u m=1
XT1307 vdd well_1307 ntap1 A=4e-12 P=8e-6
XM2_24 dm_1 net1 vdd well_1307 sg13_lv_pmos w=1u l=1u m=1
XT1308 vdd well_1308 ntap1 A=4e-12 P=8e-6
XM2_25 dm_1 net1 vdd well_1308 sg13_lv_pmos w=1u l=1u m=1
XT1309 vdd well_1309 ntap1 A=4e-12 P=8e-6
XM2_26 dm_1 net1 vdd well_1309 sg13_lv_pmos w=1u l=1u m=1
XT1310 vdd well_1310 ntap1 A=4e-12 P=8e-6
XM2_27 dm_1 net1 vdd well_1310 sg13_lv_pmos w=1u l=1u m=1
XT1311 vdd well_1311 ntap1 A=4e-12 P=8e-6
XM2_28 dm_1 net1 vdd well_1311 sg13_lv_pmos w=1u l=1u m=1
XT1312 vdd well_1312 ntap1 A=4e-12 P=8e-6
XM2_29 dm_1 net1 vdd well_1312 sg13_lv_pmos w=1u l=1u m=1
XT1313 vdd well_1313 ntap1 A=4e-12 P=8e-6
XM2_30 dm_1 net1 vdd well_1313 sg13_lv_pmos w=1u l=1u m=1
XT1314 vdd well_1314 ntap1 A=4e-12 P=8e-6
XM2_31 dm_1 net1 vdd well_1314 sg13_lv_pmos w=1u l=1u m=1
XT1315 vdd well_1315 ntap1 A=4e-12 P=8e-6
XM2_32 dm_1 net1 vdd well_1315 sg13_lv_pmos w=1u l=1u m=1
XT1316 vdd well_1316 ntap1 A=4e-12 P=8e-6
XM2_33 dm_1 net1 vdd well_1316 sg13_lv_pmos w=1u l=1u m=1
XT1317 vdd well_1317 ntap1 A=4e-12 P=8e-6
XM2_34 dm_1 net1 vdd well_1317 sg13_lv_pmos w=1u l=1u m=1
XT1318 vdd well_1318 ntap1 A=4e-12 P=8e-6
XM2_35 dm_1 net1 vdd well_1318 sg13_lv_pmos w=1u l=1u m=1
XT1319 vdd well_1319 ntap1 A=4e-12 P=8e-6
XM2_36 dm_1 net1 vdd well_1319 sg13_lv_pmos w=1u l=1u m=1
XT1320 vdd well_1320 ntap1 A=4e-12 P=8e-6
XM2_37 dm_1 net1 vdd well_1320 sg13_lv_pmos w=1u l=1u m=1
XT1321 vdd well_1321 ntap1 A=4e-12 P=8e-6
XM2_38 dm_1 net1 vdd well_1321 sg13_lv_pmos w=1u l=1u m=1
XT1322 vdd well_1322 ntap1 A=4e-12 P=8e-6
XM2_39 dm_1 net1 vdd well_1322 sg13_lv_pmos w=1u l=1u m=1
XT1323 vdd well_1323 ntap1 A=4e-12 P=8e-6
XM2_40 dm_1 net1 vdd well_1323 sg13_lv_pmos w=1u l=1u m=1
XT1324 vdd well_1324 ntap1 A=4e-12 P=8e-6
XM2_41 dm_1 net1 vdd well_1324 sg13_lv_pmos w=1u l=1u m=1
XT1325 vdd well_1325 ntap1 A=4e-12 P=8e-6
XM2_42 dm_1 net1 vdd well_1325 sg13_lv_pmos w=1u l=1u m=1
XT1326 vdd well_1326 ntap1 A=4e-12 P=8e-6
XM2_43 dm_1 net1 vdd well_1326 sg13_lv_pmos w=1u l=1u m=1
XT1327 vdd well_1327 ntap1 A=4e-12 P=8e-6
XM2_44 dm_1 net1 vdd well_1327 sg13_lv_pmos w=1u l=1u m=1
XT1328 vdd well_1328 ntap1 A=4e-12 P=8e-6
XM2_45 dm_1 net1 vdd well_1328 sg13_lv_pmos w=1u l=1u m=1
XT1329 vdd well_1329 ntap1 A=4e-12 P=8e-6
XM2_46 dm_1 net1 vdd well_1329 sg13_lv_pmos w=1u l=1u m=1
XT1330 vdd well_1330 ntap1 A=4e-12 P=8e-6
XM2_47 dm_1 net1 vdd well_1330 sg13_lv_pmos w=1u l=1u m=1
XT1331 vdd well_1331 ntap1 A=4e-12 P=8e-6
XM2_48 dm_1 net1 vdd well_1331 sg13_lv_pmos w=1u l=1u m=1
XT1332 vdd well_1332 ntap1 A=4e-12 P=8e-6
XM2_49 dm_1 net1 vdd well_1332 sg13_lv_pmos w=1u l=1u m=1
XT1333 vdd well_1333 ntap1 A=4e-12 P=8e-6
XM2_50 dm_1 net1 vdd well_1333 sg13_lv_pmos w=1u l=1u m=1
XT1334 vdd well_1334 ntap1 A=4e-12 P=8e-6
XM2_51 dm_1 net1 vdd well_1334 sg13_lv_pmos w=1u l=1u m=1
XT1335 vdd well_1335 ntap1 A=4e-12 P=8e-6
XM2_52 dm_1 net1 vdd well_1335 sg13_lv_pmos w=1u l=1u m=1
XT1336 vdd well_1336 ntap1 A=4e-12 P=8e-6
XM2_53 dm_1 net1 vdd well_1336 sg13_lv_pmos w=1u l=1u m=1
XT1337 vdd well_1337 ntap1 A=4e-12 P=8e-6
XM2_54 dm_1 net1 vdd well_1337 sg13_lv_pmos w=1u l=1u m=1
XT1338 vdd well_1338 ntap1 A=4e-12 P=8e-6
XM2_55 dm_1 net1 vdd well_1338 sg13_lv_pmos w=1u l=1u m=1
XT1339 vdd well_1339 ntap1 A=4e-12 P=8e-6
XM2_56 dm_1 net1 vdd well_1339 sg13_lv_pmos w=1u l=1u m=1
XT1340 vdd well_1340 ntap1 A=4e-12 P=8e-6
XM2_57 dm_1 net1 vdd well_1340 sg13_lv_pmos w=1u l=1u m=1
XT1341 vdd well_1341 ntap1 A=4e-12 P=8e-6
XM2_58 dm_1 net1 vdd well_1341 sg13_lv_pmos w=1u l=1u m=1
XT1342 vdd well_1342 ntap1 A=4e-12 P=8e-6
XM2_59 dm_1 net1 vdd well_1342 sg13_lv_pmos w=1u l=1u m=1
XT1343 vdd well_1343 ntap1 A=4e-12 P=8e-6
XM2_60 dm_1 net1 vdd well_1343 sg13_lv_pmos w=1u l=1u m=1
XT1344 vdd well_1344 ntap1 A=4e-12 P=8e-6
XM2_61 dm_1 net1 vdd well_1344 sg13_lv_pmos w=1u l=1u m=1
XT1345 vdd well_1345 ntap1 A=4e-12 P=8e-6
XM2_62 dm_1 net1 vdd well_1345 sg13_lv_pmos w=1u l=1u m=1
XT1346 vdd well_1346 ntap1 A=4e-12 P=8e-6
XM2_63 dm_1 net1 vdd well_1346 sg13_lv_pmos w=1u l=1u m=1
XT1347 vdd well_1347 ntap1 A=4e-12 P=8e-6
XM2_64 dm_1 net1 vdd well_1347 sg13_lv_pmos w=1u l=1u m=1
XT1348 vdd well_1348 ntap1 A=4e-12 P=8e-6
XM2_65 dm_1 net1 vdd well_1348 sg13_lv_pmos w=1u l=1u m=1
XT1349 vdd well_1349 ntap1 A=4e-12 P=8e-6
XM2_66 dm_1 net1 vdd well_1349 sg13_lv_pmos w=1u l=1u m=1
XT1350 vdd well_1350 ntap1 A=4e-12 P=8e-6
XM2_67 dm_1 net1 vdd well_1350 sg13_lv_pmos w=1u l=1u m=1
XT1351 vdd well_1351 ntap1 A=4e-12 P=8e-6
XM2_68 dm_1 net1 vdd well_1351 sg13_lv_pmos w=1u l=1u m=1
XT1352 vdd well_1352 ntap1 A=4e-12 P=8e-6
XM2_69 dm_1 net1 vdd well_1352 sg13_lv_pmos w=1u l=1u m=1
XT1353 vdd well_1353 ntap1 A=4e-12 P=8e-6
XM2_70 dm_1 net1 vdd well_1353 sg13_lv_pmos w=1u l=1u m=1
XT1354 vss sub ptap1 A=4e-12 P=8e-6
XM20_0 net063 vb4 vss sub sg13_lv_nmos w=1u l=1u m=1
XT1355 vss sub ptap1 A=4e-12 P=8e-6
XM20_1 net063 vb4 vss sub sg13_lv_nmos w=1u l=1u m=1
XT1356 vss sub ptap1 A=4e-12 P=8e-6
XM20_2 net063 vb4 vss sub sg13_lv_nmos w=1u l=1u m=1
XT1357 vss sub ptap1 A=4e-12 P=8e-6
XM20_3 net063 vb4 vss sub sg13_lv_nmos w=1u l=1u m=1
XT1358 vss sub ptap1 A=4e-12 P=8e-6
XM20_4 net063 vb4 vss sub sg13_lv_nmos w=1u l=1u m=1
XT1359 vss sub ptap1 A=4e-12 P=8e-6
XM20_5 net063 vb4 vss sub sg13_lv_nmos w=1u l=1u m=1
XT1360 vss sub ptap1 A=4e-12 P=8e-6
XM20_6 net063 vb4 vss sub sg13_lv_nmos w=1u l=1u m=1
XT1361 vss sub ptap1 A=4e-12 P=8e-6
XM20_7 net063 vb4 vss sub sg13_lv_nmos w=1u l=1u m=1
XT1362 vss sub ptap1 A=4e-12 P=8e-6
XM20_8 net063 vb4 vss sub sg13_lv_nmos w=1u l=1u m=1
XT1363 vss sub ptap1 A=4e-12 P=8e-6
XM20_9 net063 vb4 vss sub sg13_lv_nmos w=1u l=1u m=1
XT1364 vss sub ptap1 A=4e-12 P=8e-6
XM20_10 net063 vb4 vss sub sg13_lv_nmos w=1u l=1u m=1
XT1365 vss sub ptap1 A=4e-12 P=8e-6
XM20_11 net063 vb4 vss sub sg13_lv_nmos w=1u l=1u m=1
XT1366 vss sub ptap1 A=4e-12 P=8e-6
XM20_12 net063 vb4 vss sub sg13_lv_nmos w=1u l=1u m=1
XT1367 vss sub ptap1 A=4e-12 P=8e-6
XM20_13 net063 vb4 vss sub sg13_lv_nmos w=1u l=1u m=1
XT1368 vss sub ptap1 A=4e-12 P=8e-6
XM20_14 net063 vb4 vss sub sg13_lv_nmos w=1u l=1u m=1
XT1369 vss sub ptap1 A=4e-12 P=8e-6
XM20_15 net063 vb4 vss sub sg13_lv_nmos w=1u l=1u m=1
XT1370 vss sub ptap1 A=4e-12 P=8e-6
XM20_16 net063 vb4 vss sub sg13_lv_nmos w=1u l=1u m=1
XT1371 vss sub ptap1 A=4e-12 P=8e-6
XM20_17 net063 vb4 vss sub sg13_lv_nmos w=1u l=1u m=1
XT1372 vss sub ptap1 A=4e-12 P=8e-6
XM20_18 net063 vb4 vss sub sg13_lv_nmos w=1u l=1u m=1
XT1373 vss sub ptap1 A=4e-12 P=8e-6
XM20_19 net063 vb4 vss sub sg13_lv_nmos w=1u l=1u m=1
XT1374 vss sub ptap1 A=4e-12 P=8e-6
XM20_20 net063 vb4 vss sub sg13_lv_nmos w=1u l=1u m=1
XT1375 vss sub ptap1 A=4e-12 P=8e-6
XM20_21 net063 vb4 vss sub sg13_lv_nmos w=1u l=1u m=1
XT1376 vss sub ptap1 A=4e-12 P=8e-6
XM20_22 net063 vb4 vss sub sg13_lv_nmos w=1u l=1u m=1
XT1377 vss sub ptap1 A=4e-12 P=8e-6
XM20_23 net063 vb4 vss sub sg13_lv_nmos w=1u l=1u m=1
XT1378 vss sub ptap1 A=4e-12 P=8e-6
XM20_24 net063 vb4 vss sub sg13_lv_nmos w=1u l=1u m=1
XT1379 vss sub ptap1 A=4e-12 P=8e-6
XM20_25 net063 vb4 vss sub sg13_lv_nmos w=1u l=1u m=1
XT1380 vss sub ptap1 A=4e-12 P=8e-6
XM20_26 net063 vb4 vss sub sg13_lv_nmos w=1u l=1u m=1
XT1381 vss sub ptap1 A=4e-12 P=8e-6
XM20_27 net063 vb4 vss sub sg13_lv_nmos w=1u l=1u m=1
XT1382 vss sub ptap1 A=4e-12 P=8e-6
XM20_28 net063 vb4 vss sub sg13_lv_nmos w=1u l=1u m=1
XT1383 vss sub ptap1 A=4e-12 P=8e-6
XM20_29 net063 vb4 vss sub sg13_lv_nmos w=1u l=1u m=1
XT1384 vss sub ptap1 A=4e-12 P=8e-6
XM20_30 net063 vb4 vss sub sg13_lv_nmos w=1u l=1u m=1
XT1385 vss sub ptap1 A=4e-12 P=8e-6
XM20_31 net063 vb4 vss sub sg13_lv_nmos w=1u l=1u m=1
XT1386 vss sub ptap1 A=4e-12 P=8e-6
XM20_32 net063 vb4 vss sub sg13_lv_nmos w=1u l=1u m=1
XT1387 vss sub ptap1 A=4e-12 P=8e-6
XM20_33 net063 vb4 vss sub sg13_lv_nmos w=1u l=1u m=1
XT1388 vss sub ptap1 A=4e-12 P=8e-6
XM20_34 net063 vb4 vss sub sg13_lv_nmos w=1u l=1u m=1
XT1389 vss sub ptap1 A=4e-12 P=8e-6
XM20_35 net063 vb4 vss sub sg13_lv_nmos w=1u l=1u m=1
XT1390 vss sub ptap1 A=4e-12 P=8e-6
XM20_36 net063 vb4 vss sub sg13_lv_nmos w=1u l=1u m=1
XT1391 vss sub ptap1 A=4e-12 P=8e-6
XM20_37 net063 vb4 vss sub sg13_lv_nmos w=1u l=1u m=1
XT1392 vss sub ptap1 A=4e-12 P=8e-6
XM20_38 net063 vb4 vss sub sg13_lv_nmos w=1u l=1u m=1
XT1393 vss sub ptap1 A=4e-12 P=8e-6
XM20_39 net063 vb4 vss sub sg13_lv_nmos w=1u l=1u m=1
XT1394 vss sub ptap1 A=4e-12 P=8e-6
XM20_40 net063 vb4 vss sub sg13_lv_nmos w=1u l=1u m=1
XT1395 vss sub ptap1 A=4e-12 P=8e-6
XM20_41 net063 vb4 vss sub sg13_lv_nmos w=1u l=1u m=1
XT1396 vss sub ptap1 A=4e-12 P=8e-6
XM20_42 net063 vb4 vss sub sg13_lv_nmos w=1u l=1u m=1
XT1397 vss sub ptap1 A=4e-12 P=8e-6
XM20_43 net063 vb4 vss sub sg13_lv_nmos w=1u l=1u m=1
XT1398 vss sub ptap1 A=4e-12 P=8e-6
XM20_44 net063 vb4 vss sub sg13_lv_nmos w=1u l=1u m=1
XT1399 vss sub ptap1 A=4e-12 P=8e-6
XM20_45 net063 vb4 vss sub sg13_lv_nmos w=1u l=1u m=1
XT1400 vss sub ptap1 A=4e-12 P=8e-6
XM20_46 net063 vb4 vss sub sg13_lv_nmos w=1u l=1u m=1
XT1401 vss sub ptap1 A=4e-12 P=8e-6
XM20_47 net063 vb4 vss sub sg13_lv_nmos w=1u l=1u m=1
XT1402 vss sub ptap1 A=4e-12 P=8e-6
XM20_48 net063 vb4 vss sub sg13_lv_nmos w=1u l=1u m=1
XT1403 vss sub ptap1 A=4e-12 P=8e-6
XM20_49 net063 vb4 vss sub sg13_lv_nmos w=1u l=1u m=1
XT1404 vss sub ptap1 A=4e-12 P=8e-6
XM20_50 net063 vb4 vss sub sg13_lv_nmos w=1u l=1u m=1
XT1405 vss sub ptap1 A=4e-12 P=8e-6
XM20_51 net063 vb4 vss sub sg13_lv_nmos w=1u l=1u m=1
XT1406 vss sub ptap1 A=4e-12 P=8e-6
XM20_52 net063 vb4 vss sub sg13_lv_nmos w=1u l=1u m=1
XT1407 vss sub ptap1 A=4e-12 P=8e-6
XM20_53 net063 vb4 vss sub sg13_lv_nmos w=1u l=1u m=1
XT1408 vss sub ptap1 A=4e-12 P=8e-6
XM20_54 net063 vb4 vss sub sg13_lv_nmos w=1u l=1u m=1
XT1409 vss sub ptap1 A=4e-12 P=8e-6
XM20_55 net063 vb4 vss sub sg13_lv_nmos w=1u l=1u m=1
XT1410 vss sub ptap1 A=4e-12 P=8e-6
XM20_56 net063 vb4 vss sub sg13_lv_nmos w=1u l=1u m=1
XT1411 vss sub ptap1 A=4e-12 P=8e-6
XM20_57 net063 vb4 vss sub sg13_lv_nmos w=1u l=1u m=1
XT1412 vss sub ptap1 A=4e-12 P=8e-6
XM20_58 net063 vb4 vss sub sg13_lv_nmos w=1u l=1u m=1
XT1413 vss sub ptap1 A=4e-12 P=8e-6
XM20_59 net063 vb4 vss sub sg13_lv_nmos w=1u l=1u m=1
XT1414 vss sub ptap1 A=4e-12 P=8e-6
XM20_60 net063 vb4 vss sub sg13_lv_nmos w=1u l=1u m=1
XT1415 vss sub ptap1 A=4e-12 P=8e-6
XM20_61 net063 vb4 vss sub sg13_lv_nmos w=1u l=1u m=1
XT1416 vss sub ptap1 A=4e-12 P=8e-6
XM20_62 net063 vb4 vss sub sg13_lv_nmos w=1u l=1u m=1
XT1417 vss sub ptap1 A=4e-12 P=8e-6
XM20_63 net063 vb4 vss sub sg13_lv_nmos w=1u l=1u m=1
XT1418 vss sub ptap1 A=4e-12 P=8e-6
XM20_64 net063 vb4 vss sub sg13_lv_nmos w=1u l=1u m=1
XT1419 vss sub ptap1 A=4e-12 P=8e-6
XM20_65 net063 vb4 vss sub sg13_lv_nmos w=1u l=1u m=1
XT1420 vss sub ptap1 A=4e-12 P=8e-6
XM20_66 net063 vb4 vss sub sg13_lv_nmos w=1u l=1u m=1
XT1421 vss sub ptap1 A=4e-12 P=8e-6
XM20_67 net063 vb4 vss sub sg13_lv_nmos w=1u l=1u m=1
XT1422 vss sub ptap1 A=4e-12 P=8e-6
XM20_68 net063 vb4 vss sub sg13_lv_nmos w=1u l=1u m=1
XT1423 vss sub ptap1 A=4e-12 P=8e-6
XM20_69 net063 vb4 vss sub sg13_lv_nmos w=1u l=1u m=1
XT1424 vss sub ptap1 A=4e-12 P=8e-6
XM20_70 net063 vb4 vss sub sg13_lv_nmos w=1u l=1u m=1
XT1425 vss sub ptap1 A=4e-12 P=8e-6
XM20_71 net063 vb4 vss sub sg13_lv_nmos w=1u l=1u m=1
XT1426 vss sub ptap1 A=4e-12 P=8e-6
XM20_72 net063 vb4 vss sub sg13_lv_nmos w=1u l=1u m=1
XT1427 vss sub ptap1 A=4e-12 P=8e-6
XM20_73 net063 vb4 vss sub sg13_lv_nmos w=1u l=1u m=1
XT1428 vss sub ptap1 A=4e-12 P=8e-6
XM20_74 net063 vb4 vss sub sg13_lv_nmos w=1u l=1u m=1
XT1429 vss sub ptap1 A=4e-12 P=8e-6
XM20_75 net063 vb4 vss sub sg13_lv_nmos w=1u l=1u m=1
XT1430 vss sub ptap1 A=4e-12 P=8e-6
XM20_76 net063 vb4 vss sub sg13_lv_nmos w=1u l=1u m=1
XT1431 vss sub ptap1 A=4e-12 P=8e-6
XM20_77 net063 vb4 vss sub sg13_lv_nmos w=1u l=1u m=1
XT1432 vss sub ptap1 A=4e-12 P=8e-6
XM20_78 net063 vb4 vss sub sg13_lv_nmos w=1u l=1u m=1
XT1433 vss sub ptap1 A=4e-12 P=8e-6
XM20_79 net063 vb4 vss sub sg13_lv_nmos w=1u l=1u m=1
XT1434 vss sub ptap1 A=4e-12 P=8e-6
XM20_80 net063 vb4 vss sub sg13_lv_nmos w=1u l=1u m=1
XT1435 vss sub ptap1 A=4e-12 P=8e-6
XM20_81 net063 vb4 vss sub sg13_lv_nmos w=1u l=1u m=1
XT1436 vss sub ptap1 A=4e-12 P=8e-6
XM20_82 net063 vb4 vss sub sg13_lv_nmos w=1u l=1u m=1
XT1437 vss sub ptap1 A=4e-12 P=8e-6
XM20_83 net063 vb4 vss sub sg13_lv_nmos w=1u l=1u m=1
XT1438 vss sub ptap1 A=4e-12 P=8e-6
XM20_84 net063 vb4 vss sub sg13_lv_nmos w=1u l=1u m=1
XT1439 vss sub ptap1 A=4e-12 P=8e-6
XM20_85 net063 vb4 vss sub sg13_lv_nmos w=1u l=1u m=1
XT1440 vss sub ptap1 A=4e-12 P=8e-6
XM20_86 net063 vb4 vss sub sg13_lv_nmos w=1u l=1u m=1
XT1441 vss sub ptap1 A=4e-12 P=8e-6
XM20_87 net063 vb4 vss sub sg13_lv_nmos w=1u l=1u m=1
XT1442 vss sub ptap1 A=4e-12 P=8e-6
XM20_88 net063 vb4 vss sub sg13_lv_nmos w=1u l=1u m=1
XT1443 vss sub ptap1 A=4e-12 P=8e-6
XM20_89 net063 vb4 vss sub sg13_lv_nmos w=1u l=1u m=1
XT1444 vss sub ptap1 A=4e-12 P=8e-6
XM20_90 net063 vb4 vss sub sg13_lv_nmos w=1u l=1u m=1
XT1445 vss sub ptap1 A=4e-12 P=8e-6
XM20_91 net063 vb4 vss sub sg13_lv_nmos w=1u l=1u m=1
XT1446 vss sub ptap1 A=4e-12 P=8e-6
XM20_92 net063 vb4 vss sub sg13_lv_nmos w=1u l=1u m=1
XT1447 vss sub ptap1 A=4e-12 P=8e-6
XM20_93 net063 vb4 vss sub sg13_lv_nmos w=1u l=1u m=1
XT1448 vss sub ptap1 A=4e-12 P=8e-6
XM20_94 net063 vb4 vss sub sg13_lv_nmos w=1u l=1u m=1
XT1449 vss sub ptap1 A=4e-12 P=8e-6
XM20_95 net063 vb4 vss sub sg13_lv_nmos w=1u l=1u m=1
XT1450 vss sub ptap1 A=4e-12 P=8e-6
XM20_96 net063 vb4 vss sub sg13_lv_nmos w=1u l=1u m=1
XT1451 vss sub ptap1 A=4e-12 P=8e-6
XM20_97 net063 vb4 vss sub sg13_lv_nmos w=1u l=1u m=1
XT1452 vss sub ptap1 A=4e-12 P=8e-6
XM20_98 net063 vb4 vss sub sg13_lv_nmos w=1u l=1u m=1
XT1453 vss sub ptap1 A=4e-12 P=8e-6
XM20_99 net063 vb4 vss sub sg13_lv_nmos w=1u l=1u m=1
XT1454 vss sub ptap1 A=4e-12 P=8e-6
XM20_100 net063 vb4 vss sub sg13_lv_nmos w=1u l=1u m=1
XT1455 vss sub ptap1 A=4e-12 P=8e-6
XM20_101 net063 vb4 vss sub sg13_lv_nmos w=1u l=1u m=1
XT1456 vss sub ptap1 A=4e-12 P=8e-6
XM20_102 net063 vb4 vss sub sg13_lv_nmos w=1u l=1u m=1
XT1457 vss sub ptap1 A=4e-12 P=8e-6
XM20_103 net063 vb4 vss sub sg13_lv_nmos w=1u l=1u m=1
XT1458 vss sub ptap1 A=4e-12 P=8e-6
XM20_104 net063 vb4 vss sub sg13_lv_nmos w=1u l=1u m=1
XT1459 vss sub ptap1 A=4e-12 P=8e-6
XM20_105 net063 vb4 vss sub sg13_lv_nmos w=1u l=1u m=1
XT1460 vss sub ptap1 A=4e-12 P=8e-6
XM20_106 net063 vb4 vss sub sg13_lv_nmos w=1u l=1u m=1
XT1461 vss sub ptap1 A=4e-12 P=8e-6
XM20_107 net063 vb4 vss sub sg13_lv_nmos w=1u l=1u m=1
XT1462 vss sub ptap1 A=4e-12 P=8e-6
XM20_108 net063 vb4 vss sub sg13_lv_nmos w=1u l=1u m=1
XT1463 vss sub ptap1 A=4e-12 P=8e-6
XM20_109 net063 vb4 vss sub sg13_lv_nmos w=1u l=1u m=1
XT1464 vss sub ptap1 A=4e-12 P=8e-6
XM20_110 net063 vb4 vss sub sg13_lv_nmos w=1u l=1u m=1
XT1465 vss sub ptap1 A=4e-12 P=8e-6
XM20_111 net063 vb4 vss sub sg13_lv_nmos w=1u l=1u m=1
XT1466 vss sub ptap1 A=4e-12 P=8e-6
XM20_112 net063 vb4 vss sub sg13_lv_nmos w=1u l=1u m=1
XT1467 vss sub ptap1 A=4e-12 P=8e-6
XM20_113 net063 vb4 vss sub sg13_lv_nmos w=1u l=1u m=1
XT1468 vss sub ptap1 A=4e-12 P=8e-6
XM20_114 net063 vb4 vss sub sg13_lv_nmos w=1u l=1u m=1
XT1469 vss sub ptap1 A=4e-12 P=8e-6
XM20_115 net063 vb4 vss sub sg13_lv_nmos w=1u l=1u m=1
XT1470 vss sub ptap1 A=4e-12 P=8e-6
XM20_116 net063 vb4 vss sub sg13_lv_nmos w=1u l=1u m=1
XT1471 vss sub ptap1 A=4e-12 P=8e-6
XM20_117 net063 vb4 vss sub sg13_lv_nmos w=1u l=1u m=1
XT1472 vss sub ptap1 A=4e-12 P=8e-6
XM20_118 net063 vb4 vss sub sg13_lv_nmos w=1u l=1u m=1
XT1473 vss sub ptap1 A=4e-12 P=8e-6
XM20_119 net063 vb4 vss sub sg13_lv_nmos w=1u l=1u m=1
XT1474 vss sub ptap1 A=4e-12 P=8e-6
XM20_120 net063 vb4 vss sub sg13_lv_nmos w=1u l=1u m=1
XT1475 vss sub ptap1 A=4e-12 P=8e-6
XM20_121 net063 vb4 vss sub sg13_lv_nmos w=1u l=1u m=1
XT1476 vss sub ptap1 A=4e-12 P=8e-6
XM20_122 net063 vb4 vss sub sg13_lv_nmos w=1u l=1u m=1
XT1477 vss sub ptap1 A=4e-12 P=8e-6
XM20_123 net063 vb4 vss sub sg13_lv_nmos w=1u l=1u m=1
XT1478 vss sub ptap1 A=4e-12 P=8e-6
XM20_124 net063 vb4 vss sub sg13_lv_nmos w=1u l=1u m=1
XT1479 vss sub ptap1 A=4e-12 P=8e-6
XM20_125 net063 vb4 vss sub sg13_lv_nmos w=1u l=1u m=1
XT1480 vss sub ptap1 A=4e-12 P=8e-6
XM20_126 net063 vb4 vss sub sg13_lv_nmos w=1u l=1u m=1
XT1481 vss sub ptap1 A=4e-12 P=8e-6
XM20_127 net063 vb4 vss sub sg13_lv_nmos w=1u l=1u m=1
XT1482 vss sub ptap1 A=4e-12 P=8e-6
XM20_128 net063 vb4 vss sub sg13_lv_nmos w=1u l=1u m=1
XT1483 vss sub ptap1 A=4e-12 P=8e-6
XM20_129 net063 vb4 vss sub sg13_lv_nmos w=1u l=1u m=1
XT1484 vss sub ptap1 A=4e-12 P=8e-6
XM20_130 net063 vb4 vss sub sg13_lv_nmos w=1u l=1u m=1
XT1485 vss sub ptap1 A=4e-12 P=8e-6
XM20_131 net063 vb4 vss sub sg13_lv_nmos w=1u l=1u m=1
XT1486 vss sub ptap1 A=4e-12 P=8e-6
XM20_132 net063 vb4 vss sub sg13_lv_nmos w=1u l=1u m=1
XT1487 vss sub ptap1 A=4e-12 P=8e-6
XM20_133 net063 vb4 vss sub sg13_lv_nmos w=1u l=1u m=1
XT1488 vss sub ptap1 A=4e-12 P=8e-6
XM20_134 net063 vb4 vss sub sg13_lv_nmos w=1u l=1u m=1
XT1489 vss sub ptap1 A=4e-12 P=8e-6
XM20_135 net063 vb4 vss sub sg13_lv_nmos w=1u l=1u m=1
XT1490 vss sub ptap1 A=4e-12 P=8e-6
XM20_136 net063 vb4 vss sub sg13_lv_nmos w=1u l=1u m=1
XT1491 vss sub ptap1 A=4e-12 P=8e-6
XM20_137 net063 vb4 vss sub sg13_lv_nmos w=1u l=1u m=1
XT1492 vss sub ptap1 A=4e-12 P=8e-6
XM20_138 net063 vb4 vss sub sg13_lv_nmos w=1u l=1u m=1
XT1493 vss sub ptap1 A=4e-12 P=8e-6
XM20_139 net063 vb4 vss sub sg13_lv_nmos w=1u l=1u m=1
XT1494 vss sub ptap1 A=4e-12 P=8e-6
XM20_140 net063 vb4 vss sub sg13_lv_nmos w=1u l=1u m=1
XT1495 vss sub ptap1 A=4e-12 P=8e-6
XM20_141 net063 vb4 vss sub sg13_lv_nmos w=1u l=1u m=1
XT1496 vss sub ptap1 A=4e-12 P=8e-6
XM20_142 net063 vb4 vss sub sg13_lv_nmos w=1u l=1u m=1
XT1497 vss sub ptap1 A=4e-12 P=8e-6
XM20_143 net063 vb4 vss sub sg13_lv_nmos w=1u l=1u m=1
XT1498 vss sub ptap1 A=4e-12 P=8e-6
XM20_144 net063 vb4 vss sub sg13_lv_nmos w=1u l=1u m=1
XT1499 vss sub ptap1 A=4e-12 P=8e-6
XM20_145 net063 vb4 vss sub sg13_lv_nmos w=1u l=1u m=1
XT1500 vss sub ptap1 A=4e-12 P=8e-6
XM20_146 net063 vb4 vss sub sg13_lv_nmos w=1u l=1u m=1
XT1501 vss sub ptap1 A=4e-12 P=8e-6
XM20_147 net063 vb4 vss sub sg13_lv_nmos w=1u l=1u m=1
XT1502 vss sub ptap1 A=4e-12 P=8e-6
XM20_148 net063 vb4 vss sub sg13_lv_nmos w=1u l=1u m=1
XT1503 vss sub ptap1 A=4e-12 P=8e-6
XM20_149 net063 vb4 vss sub sg13_lv_nmos w=1u l=1u m=1
XT1504 vss sub ptap1 A=4e-12 P=8e-6
XM20_150 net063 vb4 vss sub sg13_lv_nmos w=1u l=1u m=1
XT1505 vss sub ptap1 A=4e-12 P=8e-6
XM20_151 net063 vb4 vss sub sg13_lv_nmos w=1u l=1u m=1
XT1506 vss sub ptap1 A=4e-12 P=8e-6
XM20_152 net063 vb4 vss sub sg13_lv_nmos w=1u l=1u m=1
XT1507 vss sub ptap1 A=4e-12 P=8e-6
XM20_153 net063 vb4 vss sub sg13_lv_nmos w=1u l=1u m=1
XT1508 vss sub ptap1 A=4e-12 P=8e-6
XM20_154 net063 vb4 vss sub sg13_lv_nmos w=1u l=1u m=1
XT1509 vss sub ptap1 A=4e-12 P=8e-6
XM20_155 net063 vb4 vss sub sg13_lv_nmos w=1u l=1u m=1
XT1510 vss sub ptap1 A=4e-12 P=8e-6
XM20_156 net063 vb4 vss sub sg13_lv_nmos w=1u l=1u m=1
XT1511 vss sub ptap1 A=4e-12 P=8e-6
XM20_157 net063 vb4 vss sub sg13_lv_nmos w=1u l=1u m=1
XT1512 vss sub ptap1 A=4e-12 P=8e-6
XM20_158 net063 vb4 vss sub sg13_lv_nmos w=1u l=1u m=1
XT1513 vss sub ptap1 A=4e-12 P=8e-6
XM20_159 net063 vb4 vss sub sg13_lv_nmos w=1u l=1u m=1
XT1514 vss sub ptap1 A=4e-12 P=8e-6
XM21 net043 net043 vss sub sg13_lv_nmos w=1u l=1u m=1
XT1515 vss sub ptap1 A=4e-12 P=8e-6
XM22 net049 net043 vss sub sg13_lv_nmos w=1u l=1u m=1
XT1516 vss sub ptap1 A=4e-12 P=8e-6
XM23_0 vout net049 vss sub sg13_lv_nmos w=1u l=1u m=1
XT1517 vss sub ptap1 A=4e-12 P=8e-6
XM23_1 vout net049 vss sub sg13_lv_nmos w=1u l=1u m=1
XT1518 vss sub ptap1 A=4e-12 P=8e-6
XM23_2 vout net049 vss sub sg13_lv_nmos w=1u l=1u m=1
XT1519 vss sub ptap1 A=4e-12 P=8e-6
XM23_3 vout net049 vss sub sg13_lv_nmos w=1u l=1u m=1
XT1520 vss sub ptap1 A=4e-12 P=8e-6
XM23_4 vout net049 vss sub sg13_lv_nmos w=1u l=1u m=1
XT1521 vss sub ptap1 A=4e-12 P=8e-6
XM23_5 vout net049 vss sub sg13_lv_nmos w=1u l=1u m=1
XT1522 vss sub ptap1 A=4e-12 P=8e-6
XM23_6 vout net049 vss sub sg13_lv_nmos w=1u l=1u m=1
XT1523 vss sub ptap1 A=4e-12 P=8e-6
XM23_7 vout net049 vss sub sg13_lv_nmos w=1u l=1u m=1
XT1524 vss sub ptap1 A=4e-12 P=8e-6
XM23_8 vout net049 vss sub sg13_lv_nmos w=1u l=1u m=1
XT1525 vss sub ptap1 A=4e-12 P=8e-6
XM23_9 vout net049 vss sub sg13_lv_nmos w=1u l=1u m=1
XT1526 vss sub ptap1 A=4e-12 P=8e-6
XM23_10 vout net049 vss sub sg13_lv_nmos w=1u l=1u m=1
XT1527 vss sub ptap1 A=4e-12 P=8e-6
XM23_11 vout net049 vss sub sg13_lv_nmos w=1u l=1u m=1
XT1528 vss sub ptap1 A=4e-12 P=8e-6
XM23_12 vout net049 vss sub sg13_lv_nmos w=1u l=1u m=1
XT1529 vss sub ptap1 A=4e-12 P=8e-6
XM23_13 vout net049 vss sub sg13_lv_nmos w=1u l=1u m=1
XT1530 vss sub ptap1 A=4e-12 P=8e-6
XM23_14 vout net049 vss sub sg13_lv_nmos w=1u l=1u m=1
XT1531 vss sub ptap1 A=4e-12 P=8e-6
XM23_15 vout net049 vss sub sg13_lv_nmos w=1u l=1u m=1
XT1532 vss sub ptap1 A=4e-12 P=8e-6
XM23_16 vout net049 vss sub sg13_lv_nmos w=1u l=1u m=1
XT1533 vss sub ptap1 A=4e-12 P=8e-6
XM23_17 vout net049 vss sub sg13_lv_nmos w=1u l=1u m=1
XT1534 vss sub ptap1 A=4e-12 P=8e-6
XM23_18 vout net049 vss sub sg13_lv_nmos w=1u l=1u m=1
XT1535 vss sub ptap1 A=4e-12 P=8e-6
XM23_19 vout net049 vss sub sg13_lv_nmos w=1u l=1u m=1
XT1536 vss sub ptap1 A=4e-12 P=8e-6
XM23_20 vout net049 vss sub sg13_lv_nmos w=1u l=1u m=1
XT1537 vss sub ptap1 A=4e-12 P=8e-6
XM23_21 vout net049 vss sub sg13_lv_nmos w=1u l=1u m=1
XT1538 vss sub ptap1 A=4e-12 P=8e-6
XM23_22 vout net049 vss sub sg13_lv_nmos w=1u l=1u m=1
XT1539 vss sub ptap1 A=4e-12 P=8e-6
XM23_23 vout net049 vss sub sg13_lv_nmos w=1u l=1u m=1
XT1540 vss sub ptap1 A=4e-12 P=8e-6
XM23_24 vout net049 vss sub sg13_lv_nmos w=1u l=1u m=1
XT1541 vss sub ptap1 A=4e-12 P=8e-6
XM23_25 vout net049 vss sub sg13_lv_nmos w=1u l=1u m=1
XT1542 vss sub ptap1 A=4e-12 P=8e-6
XM23_26 vout net049 vss sub sg13_lv_nmos w=1u l=1u m=1
XT1543 vss sub ptap1 A=4e-12 P=8e-6
XM23_27 vout net049 vss sub sg13_lv_nmos w=1u l=1u m=1
XT1544 vss sub ptap1 A=4e-12 P=8e-6
XM23_28 vout net049 vss sub sg13_lv_nmos w=1u l=1u m=1
XT1545 vss sub ptap1 A=4e-12 P=8e-6
XM23_29 vout net049 vss sub sg13_lv_nmos w=1u l=1u m=1
XT1546 vss sub ptap1 A=4e-12 P=8e-6
XM23_30 vout net049 vss sub sg13_lv_nmos w=1u l=1u m=1
XT1547 vss sub ptap1 A=4e-12 P=8e-6
XM23_31 vout net049 vss sub sg13_lv_nmos w=1u l=1u m=1
XT1548 vss sub ptap1 A=4e-12 P=8e-6
XM23_32 vout net049 vss sub sg13_lv_nmos w=1u l=1u m=1
XT1549 vss sub ptap1 A=4e-12 P=8e-6
XM23_33 vout net049 vss sub sg13_lv_nmos w=1u l=1u m=1
XT1550 vss sub ptap1 A=4e-12 P=8e-6
XM23_34 vout net049 vss sub sg13_lv_nmos w=1u l=1u m=1
XT1551 vss sub ptap1 A=4e-12 P=8e-6
XM23_35 vout net049 vss sub sg13_lv_nmos w=1u l=1u m=1
XT1552 vss sub ptap1 A=4e-12 P=8e-6
XM23_36 vout net049 vss sub sg13_lv_nmos w=1u l=1u m=1
XT1553 vss sub ptap1 A=4e-12 P=8e-6
XM23_37 vout net049 vss sub sg13_lv_nmos w=1u l=1u m=1
XT1554 vss sub ptap1 A=4e-12 P=8e-6
XM23_38 vout net049 vss sub sg13_lv_nmos w=1u l=1u m=1
XT1555 vss sub ptap1 A=4e-12 P=8e-6
XM23_39 vout net049 vss sub sg13_lv_nmos w=1u l=1u m=1
XT1556 vss sub ptap1 A=4e-12 P=8e-6
XM23_40 vout net049 vss sub sg13_lv_nmos w=1u l=1u m=1
XT1557 vss sub ptap1 A=4e-12 P=8e-6
XM23_41 vout net049 vss sub sg13_lv_nmos w=1u l=1u m=1
XT1558 vss sub ptap1 A=4e-12 P=8e-6
XM23_42 vout net049 vss sub sg13_lv_nmos w=1u l=1u m=1
XT1559 vss sub ptap1 A=4e-12 P=8e-6
XM23_43 vout net049 vss sub sg13_lv_nmos w=1u l=1u m=1
XT1560 vss sub ptap1 A=4e-12 P=8e-6
XM23_44 vout net049 vss sub sg13_lv_nmos w=1u l=1u m=1
XT1561 vss sub ptap1 A=4e-12 P=8e-6
XM23_45 vout net049 vss sub sg13_lv_nmos w=1u l=1u m=1
XT1562 vss sub ptap1 A=4e-12 P=8e-6
XM23_46 vout net049 vss sub sg13_lv_nmos w=1u l=1u m=1
XT1563 vss sub ptap1 A=4e-12 P=8e-6
XM23_47 vout net049 vss sub sg13_lv_nmos w=1u l=1u m=1
XT1564 vss sub ptap1 A=4e-12 P=8e-6
XM23_48 vout net049 vss sub sg13_lv_nmos w=1u l=1u m=1
XT1565 vss sub ptap1 A=4e-12 P=8e-6
XM23_49 vout net049 vss sub sg13_lv_nmos w=1u l=1u m=1
XT1566 vss sub ptap1 A=4e-12 P=8e-6
XM23_50 vout net049 vss sub sg13_lv_nmos w=1u l=1u m=1
XT1567 vss sub ptap1 A=4e-12 P=8e-6
XM23_51 vout net049 vss sub sg13_lv_nmos w=1u l=1u m=1
XT1568 vss sub ptap1 A=4e-12 P=8e-6
XM23_52 vout net049 vss sub sg13_lv_nmos w=1u l=1u m=1
XT1569 vss sub ptap1 A=4e-12 P=8e-6
XM23_53 vout net049 vss sub sg13_lv_nmos w=1u l=1u m=1
XT1570 vss sub ptap1 A=4e-12 P=8e-6
XM23_54 vout net049 vss sub sg13_lv_nmos w=1u l=1u m=1
XT1571 vss sub ptap1 A=4e-12 P=8e-6
XM23_55 vout net049 vss sub sg13_lv_nmos w=1u l=1u m=1
XT1572 vss sub ptap1 A=4e-12 P=8e-6
XM23_56 vout net049 vss sub sg13_lv_nmos w=1u l=1u m=1
XT1573 vss sub ptap1 A=4e-12 P=8e-6
XM23_57 vout net049 vss sub sg13_lv_nmos w=1u l=1u m=1
XT1574 vss sub ptap1 A=4e-12 P=8e-6
XM23_58 vout net049 vss sub sg13_lv_nmos w=1u l=1u m=1
XT1575 vss sub ptap1 A=4e-12 P=8e-6
XM23_59 vout net049 vss sub sg13_lv_nmos w=1u l=1u m=1
XT1576 vss sub ptap1 A=4e-12 P=8e-6
XM23_60 vout net049 vss sub sg13_lv_nmos w=1u l=1u m=1
XT1577 vss sub ptap1 A=4e-12 P=8e-6
XM23_61 vout net049 vss sub sg13_lv_nmos w=1u l=1u m=1
XT1578 vss sub ptap1 A=4e-12 P=8e-6
XM23_62 vout net049 vss sub sg13_lv_nmos w=1u l=1u m=1
XT1579 vss sub ptap1 A=4e-12 P=8e-6
XM23_63 vout net049 vss sub sg13_lv_nmos w=1u l=1u m=1
XT1580 vss sub ptap1 A=4e-12 P=8e-6
XM23_64 vout net049 vss sub sg13_lv_nmos w=1u l=1u m=1
XT1581 vss sub ptap1 A=4e-12 P=8e-6
XM23_65 vout net049 vss sub sg13_lv_nmos w=1u l=1u m=1
XT1582 vss sub ptap1 A=4e-12 P=8e-6
XM23_66 vout net049 vss sub sg13_lv_nmos w=1u l=1u m=1
XT1583 vss sub ptap1 A=4e-12 P=8e-6
XM23_67 vout net049 vss sub sg13_lv_nmos w=1u l=1u m=1
XT1584 vss sub ptap1 A=4e-12 P=8e-6
XM23_68 vout net049 vss sub sg13_lv_nmos w=1u l=1u m=1
XT1585 vss sub ptap1 A=4e-12 P=8e-6
XM23_69 vout net049 vss sub sg13_lv_nmos w=1u l=1u m=1
XT1586 vss sub ptap1 A=4e-12 P=8e-6
XM23_70 vout net049 vss sub sg13_lv_nmos w=1u l=1u m=1
XT1587 vss sub ptap1 A=4e-12 P=8e-6
XM23_71 vout net049 vss sub sg13_lv_nmos w=1u l=1u m=1
XT1588 vss sub ptap1 A=4e-12 P=8e-6
XM23_72 vout net049 vss sub sg13_lv_nmos w=1u l=1u m=1
XT1589 vss sub ptap1 A=4e-12 P=8e-6
XM23_73 vout net049 vss sub sg13_lv_nmos w=1u l=1u m=1
XT1590 vss sub ptap1 A=4e-12 P=8e-6
XM23_74 vout net049 vss sub sg13_lv_nmos w=1u l=1u m=1
XT1591 vss sub ptap1 A=4e-12 P=8e-6
XM23_75 vout net049 vss sub sg13_lv_nmos w=1u l=1u m=1
XT1592 vss sub ptap1 A=4e-12 P=8e-6
XM23_76 vout net049 vss sub sg13_lv_nmos w=1u l=1u m=1
XT1593 vss sub ptap1 A=4e-12 P=8e-6
XM23_77 vout net049 vss sub sg13_lv_nmos w=1u l=1u m=1
XT1594 vss sub ptap1 A=4e-12 P=8e-6
XM23_78 vout net049 vss sub sg13_lv_nmos w=1u l=1u m=1
XT1595 vss sub ptap1 A=4e-12 P=8e-6
XM23_79 vout net049 vss sub sg13_lv_nmos w=1u l=1u m=1
XT1596 vss sub ptap1 A=4e-12 P=8e-6
XM23_80 vout net049 vss sub sg13_lv_nmos w=1u l=1u m=1
XT1597 vss sub ptap1 A=4e-12 P=8e-6
XM23_81 vout net049 vss sub sg13_lv_nmos w=1u l=1u m=1
XT1598 vss sub ptap1 A=4e-12 P=8e-6
XM23_82 vout net049 vss sub sg13_lv_nmos w=1u l=1u m=1
XT1599 vss sub ptap1 A=4e-12 P=8e-6
XM23_83 vout net049 vss sub sg13_lv_nmos w=1u l=1u m=1
XT1600 vss sub ptap1 A=4e-12 P=8e-6
XM23_84 vout net049 vss sub sg13_lv_nmos w=1u l=1u m=1
XT1601 vss sub ptap1 A=4e-12 P=8e-6
XM23_85 vout net049 vss sub sg13_lv_nmos w=1u l=1u m=1
XT1602 vss sub ptap1 A=4e-12 P=8e-6
XM23_86 vout net049 vss sub sg13_lv_nmos w=1u l=1u m=1
XT1603 vss sub ptap1 A=4e-12 P=8e-6
XM23_87 vout net049 vss sub sg13_lv_nmos w=1u l=1u m=1
XT1604 vss sub ptap1 A=4e-12 P=8e-6
XM23_88 vout net049 vss sub sg13_lv_nmos w=1u l=1u m=1
XT1605 vss sub ptap1 A=4e-12 P=8e-6
XM23_89 vout net049 vss sub sg13_lv_nmos w=1u l=1u m=1
XT1606 vss sub ptap1 A=4e-12 P=8e-6
XM23_90 vout net049 vss sub sg13_lv_nmos w=1u l=1u m=1
XT1607 vss sub ptap1 A=4e-12 P=8e-6
XM23_91 vout net049 vss sub sg13_lv_nmos w=1u l=1u m=1
XT1608 vss sub ptap1 A=4e-12 P=8e-6
XM23_92 vout net049 vss sub sg13_lv_nmos w=1u l=1u m=1
XT1609 vss sub ptap1 A=4e-12 P=8e-6
XM23_93 vout net049 vss sub sg13_lv_nmos w=1u l=1u m=1
XT1610 vss sub ptap1 A=4e-12 P=8e-6
XM23_94 vout net049 vss sub sg13_lv_nmos w=1u l=1u m=1
XT1611 vss sub ptap1 A=4e-12 P=8e-6
XM23_95 vout net049 vss sub sg13_lv_nmos w=1u l=1u m=1
XT1612 vss sub ptap1 A=4e-12 P=8e-6
XM23_96 vout net049 vss sub sg13_lv_nmos w=1u l=1u m=1
XT1613 vss sub ptap1 A=4e-12 P=8e-6
XM23_97 vout net049 vss sub sg13_lv_nmos w=1u l=1u m=1
XT1614 vss sub ptap1 A=4e-12 P=8e-6
XM23_98 vout net049 vss sub sg13_lv_nmos w=1u l=1u m=1
XT1615 vss sub ptap1 A=4e-12 P=8e-6
XM23_99 vout net049 vss sub sg13_lv_nmos w=1u l=1u m=1
XT1616 vss sub ptap1 A=4e-12 P=8e-6
XM23_100 vout net049 vss sub sg13_lv_nmos w=1u l=1u m=1
XT1617 vss sub ptap1 A=4e-12 P=8e-6
XM23_101 vout net049 vss sub sg13_lv_nmos w=1u l=1u m=1
XT1618 vss sub ptap1 A=4e-12 P=8e-6
XM23_102 vout net049 vss sub sg13_lv_nmos w=1u l=1u m=1
XT1619 vss sub ptap1 A=4e-12 P=8e-6
XM23_103 vout net049 vss sub sg13_lv_nmos w=1u l=1u m=1
XT1620 vss sub ptap1 A=4e-12 P=8e-6
XM23_104 vout net049 vss sub sg13_lv_nmos w=1u l=1u m=1
XT1621 vss sub ptap1 A=4e-12 P=8e-6
XM23_105 vout net049 vss sub sg13_lv_nmos w=1u l=1u m=1
XT1622 vss sub ptap1 A=4e-12 P=8e-6
XM23_106 vout net049 vss sub sg13_lv_nmos w=1u l=1u m=1
XT1623 vss sub ptap1 A=4e-12 P=8e-6
XM23_107 vout net049 vss sub sg13_lv_nmos w=1u l=1u m=1
XT1624 vss sub ptap1 A=4e-12 P=8e-6
XM23_108 vout net049 vss sub sg13_lv_nmos w=1u l=1u m=1
XT1625 vss sub ptap1 A=4e-12 P=8e-6
XM23_109 vout net049 vss sub sg13_lv_nmos w=1u l=1u m=1
XT1626 vss sub ptap1 A=4e-12 P=8e-6
XM23_110 vout net049 vss sub sg13_lv_nmos w=1u l=1u m=1
XT1627 vss sub ptap1 A=4e-12 P=8e-6
XM23_111 vout net049 vss sub sg13_lv_nmos w=1u l=1u m=1
XT1628 vss sub ptap1 A=4e-12 P=8e-6
XM23_112 vout net049 vss sub sg13_lv_nmos w=1u l=1u m=1
XT1629 vss sub ptap1 A=4e-12 P=8e-6
XM23_113 vout net049 vss sub sg13_lv_nmos w=1u l=1u m=1
XT1630 vss sub ptap1 A=4e-12 P=8e-6
XM23_114 vout net049 vss sub sg13_lv_nmos w=1u l=1u m=1
XT1631 vss sub ptap1 A=4e-12 P=8e-6
XM23_115 vout net049 vss sub sg13_lv_nmos w=1u l=1u m=1
XT1632 vss sub ptap1 A=4e-12 P=8e-6
XM23_116 vout net049 vss sub sg13_lv_nmos w=1u l=1u m=1
XT1633 vss sub ptap1 A=4e-12 P=8e-6
XM23_117 vout net049 vss sub sg13_lv_nmos w=1u l=1u m=1
XT1634 vss sub ptap1 A=4e-12 P=8e-6
XM23_118 vout net049 vss sub sg13_lv_nmos w=1u l=1u m=1
XT1635 vss sub ptap1 A=4e-12 P=8e-6
XM23_119 vout net049 vss sub sg13_lv_nmos w=1u l=1u m=1
XT1636 vss sub ptap1 A=4e-12 P=8e-6
XM23_120 vout net049 vss sub sg13_lv_nmos w=1u l=1u m=1
XT1637 vss sub ptap1 A=4e-12 P=8e-6
XM23_121 vout net049 vss sub sg13_lv_nmos w=1u l=1u m=1
XT1638 vss sub ptap1 A=4e-12 P=8e-6
XM23_122 vout net049 vss sub sg13_lv_nmos w=1u l=1u m=1
XT1639 vss sub ptap1 A=4e-12 P=8e-6
XM23_123 vout net049 vss sub sg13_lv_nmos w=1u l=1u m=1
XT1640 vss sub ptap1 A=4e-12 P=8e-6
XM23_124 vout net049 vss sub sg13_lv_nmos w=1u l=1u m=1
XT1641 vss sub ptap1 A=4e-12 P=8e-6
XM23_125 vout net049 vss sub sg13_lv_nmos w=1u l=1u m=1
XT1642 vss sub ptap1 A=4e-12 P=8e-6
XM23_126 vout net049 vss sub sg13_lv_nmos w=1u l=1u m=1
XT1643 vss sub ptap1 A=4e-12 P=8e-6
XM23_127 vout net049 vss sub sg13_lv_nmos w=1u l=1u m=1
XT1644 vss sub ptap1 A=4e-12 P=8e-6
XM23_128 vout net049 vss sub sg13_lv_nmos w=1u l=1u m=1
XT1645 vss sub ptap1 A=4e-12 P=8e-6
XM23_129 vout net049 vss sub sg13_lv_nmos w=1u l=1u m=1
XT1646 vss sub ptap1 A=4e-12 P=8e-6
XM23_130 vout net049 vss sub sg13_lv_nmos w=1u l=1u m=1
XT1647 vss sub ptap1 A=4e-12 P=8e-6
XM23_131 vout net049 vss sub sg13_lv_nmos w=1u l=1u m=1
XT1648 vss sub ptap1 A=4e-12 P=8e-6
XM23_132 vout net049 vss sub sg13_lv_nmos w=1u l=1u m=1
XT1649 vss sub ptap1 A=4e-12 P=8e-6
XM23_133 vout net049 vss sub sg13_lv_nmos w=1u l=1u m=1
XT1650 vss sub ptap1 A=4e-12 P=8e-6
XM23_134 vout net049 vss sub sg13_lv_nmos w=1u l=1u m=1
XT1651 vss sub ptap1 A=4e-12 P=8e-6
XM23_135 vout net049 vss sub sg13_lv_nmos w=1u l=1u m=1
XT1652 vss sub ptap1 A=4e-12 P=8e-6
XM23_136 vout net049 vss sub sg13_lv_nmos w=1u l=1u m=1
XT1653 vss sub ptap1 A=4e-12 P=8e-6
XM23_137 vout net049 vss sub sg13_lv_nmos w=1u l=1u m=1
XT1654 vss sub ptap1 A=4e-12 P=8e-6
XM23_138 vout net049 vss sub sg13_lv_nmos w=1u l=1u m=1
XT1655 vss sub ptap1 A=4e-12 P=8e-6
XM23_139 vout net049 vss sub sg13_lv_nmos w=1u l=1u m=1
XT1656 vss sub ptap1 A=4e-12 P=8e-6
XM23_140 vout net049 vss sub sg13_lv_nmos w=1u l=1u m=1
XT1657 vss sub ptap1 A=4e-12 P=8e-6
XM23_141 vout net049 vss sub sg13_lv_nmos w=1u l=1u m=1
XT1658 vss sub ptap1 A=4e-12 P=8e-6
XM23_142 vout net049 vss sub sg13_lv_nmos w=1u l=1u m=1
XT1659 vss sub ptap1 A=4e-12 P=8e-6
XM23_143 vout net049 vss sub sg13_lv_nmos w=1u l=1u m=1
XT1660 vss sub ptap1 A=4e-12 P=8e-6
XM23_144 vout net049 vss sub sg13_lv_nmos w=1u l=1u m=1
XT1661 vss sub ptap1 A=4e-12 P=8e-6
XM23_145 vout net049 vss sub sg13_lv_nmos w=1u l=1u m=1
XT1662 vss sub ptap1 A=4e-12 P=8e-6
XM23_146 vout net049 vss sub sg13_lv_nmos w=1u l=1u m=1
XT1663 vss sub ptap1 A=4e-12 P=8e-6
XM23_147 vout net049 vss sub sg13_lv_nmos w=1u l=1u m=1
XT1664 vss sub ptap1 A=4e-12 P=8e-6
XM23_148 vout net049 vss sub sg13_lv_nmos w=1u l=1u m=1
XT1665 vss sub ptap1 A=4e-12 P=8e-6
XM23_149 vout net049 vss sub sg13_lv_nmos w=1u l=1u m=1
XT1666 vss sub ptap1 A=4e-12 P=8e-6
XM23_150 vout net049 vss sub sg13_lv_nmos w=1u l=1u m=1
XT1667 vss sub ptap1 A=4e-12 P=8e-6
XM23_151 vout net049 vss sub sg13_lv_nmos w=1u l=1u m=1
XT1668 vss sub ptap1 A=4e-12 P=8e-6
XM23_152 vout net049 vss sub sg13_lv_nmos w=1u l=1u m=1
XT1669 vss sub ptap1 A=4e-12 P=8e-6
XM23_153 vout net049 vss sub sg13_lv_nmos w=1u l=1u m=1
XT1670 vss sub ptap1 A=4e-12 P=8e-6
XM23_154 vout net049 vss sub sg13_lv_nmos w=1u l=1u m=1
XT1671 vss sub ptap1 A=4e-12 P=8e-6
XM23_155 vout net049 vss sub sg13_lv_nmos w=1u l=1u m=1
XT1672 vss sub ptap1 A=4e-12 P=8e-6
XM23_156 vout net049 vss sub sg13_lv_nmos w=1u l=1u m=1
XT1673 vss sub ptap1 A=4e-12 P=8e-6
XM23_157 vout net049 vss sub sg13_lv_nmos w=1u l=1u m=1
XT1674 vss sub ptap1 A=4e-12 P=8e-6
XM23_158 vout net049 vss sub sg13_lv_nmos w=1u l=1u m=1
XT1675 vss sub ptap1 A=4e-12 P=8e-6
XM23_159 vout net049 vss sub sg13_lv_nmos w=1u l=1u m=1
XT1676 vss sub ptap1 A=4e-12 P=8e-6
XM23_160 vout net049 vss sub sg13_lv_nmos w=1u l=1u m=1
XT1677 vss sub ptap1 A=4e-12 P=8e-6
XM23_161 vout net049 vss sub sg13_lv_nmos w=1u l=1u m=1
XT1678 vss sub ptap1 A=4e-12 P=8e-6
XM23_162 vout net049 vss sub sg13_lv_nmos w=1u l=1u m=1
XT1679 vss sub ptap1 A=4e-12 P=8e-6
XM23_163 vout net049 vss sub sg13_lv_nmos w=1u l=1u m=1
XT1680 vss sub ptap1 A=4e-12 P=8e-6
XM23_164 vout net049 vss sub sg13_lv_nmos w=1u l=1u m=1
XT1681 vss sub ptap1 A=4e-12 P=8e-6
XM23_165 vout net049 vss sub sg13_lv_nmos w=1u l=1u m=1
XT1682 vss sub ptap1 A=4e-12 P=8e-6
XM23_166 vout net049 vss sub sg13_lv_nmos w=1u l=1u m=1
XT1683 vss sub ptap1 A=4e-12 P=8e-6
XM23_167 vout net049 vss sub sg13_lv_nmos w=1u l=1u m=1
XT1684 vss sub ptap1 A=4e-12 P=8e-6
XM23_168 vout net049 vss sub sg13_lv_nmos w=1u l=1u m=1
XT1685 vss sub ptap1 A=4e-12 P=8e-6
XM23_169 vout net049 vss sub sg13_lv_nmos w=1u l=1u m=1
XT1686 vss sub ptap1 A=4e-12 P=8e-6
XM23_170 vout net049 vss sub sg13_lv_nmos w=1u l=1u m=1
XT1687 vss sub ptap1 A=4e-12 P=8e-6
XM23_171 vout net049 vss sub sg13_lv_nmos w=1u l=1u m=1
XT1688 vss sub ptap1 A=4e-12 P=8e-6
XM23_172 vout net049 vss sub sg13_lv_nmos w=1u l=1u m=1
XT1689 vss sub ptap1 A=4e-12 P=8e-6
XM23_173 vout net049 vss sub sg13_lv_nmos w=1u l=1u m=1
XT1690 vss sub ptap1 A=4e-12 P=8e-6
XM23_174 vout net049 vss sub sg13_lv_nmos w=1u l=1u m=1
XT1691 vss sub ptap1 A=4e-12 P=8e-6
XM23_175 vout net049 vss sub sg13_lv_nmos w=1u l=1u m=1
XT1692 vss sub ptap1 A=4e-12 P=8e-6
XM23_176 vout net049 vss sub sg13_lv_nmos w=1u l=1u m=1
XT1693 vss sub ptap1 A=4e-12 P=8e-6
XM23_177 vout net049 vss sub sg13_lv_nmos w=1u l=1u m=1
XT1694 vss sub ptap1 A=4e-12 P=8e-6
XM23_178 vout net049 vss sub sg13_lv_nmos w=1u l=1u m=1
XT1695 vss sub ptap1 A=4e-12 P=8e-6
XM23_179 vout net049 vss sub sg13_lv_nmos w=1u l=1u m=1
XT1696 vss sub ptap1 A=4e-12 P=8e-6
XM23_180 vout net049 vss sub sg13_lv_nmos w=1u l=1u m=1
XT1697 vss sub ptap1 A=4e-12 P=8e-6
XM23_181 vout net049 vss sub sg13_lv_nmos w=1u l=1u m=1
XT1698 vss sub ptap1 A=4e-12 P=8e-6
XM23_182 vout net049 vss sub sg13_lv_nmos w=1u l=1u m=1
XT1699 vss sub ptap1 A=4e-12 P=8e-6
XM23_183 vout net049 vss sub sg13_lv_nmos w=1u l=1u m=1
XT1700 vss sub ptap1 A=4e-12 P=8e-6
XM23_184 vout net049 vss sub sg13_lv_nmos w=1u l=1u m=1
XT1701 vss sub ptap1 A=4e-12 P=8e-6
XM23_185 vout net049 vss sub sg13_lv_nmos w=1u l=1u m=1
XT1702 vss sub ptap1 A=4e-12 P=8e-6
XM23_186 vout net049 vss sub sg13_lv_nmos w=1u l=1u m=1
XT1703 vss sub ptap1 A=4e-12 P=8e-6
XM23_187 vout net049 vss sub sg13_lv_nmos w=1u l=1u m=1
XT1704 vss sub ptap1 A=4e-12 P=8e-6
XM23_188 vout net049 vss sub sg13_lv_nmos w=1u l=1u m=1
XT1705 vss sub ptap1 A=4e-12 P=8e-6
XM23_189 vout net049 vss sub sg13_lv_nmos w=1u l=1u m=1
XT1706 vss sub ptap1 A=4e-12 P=8e-6
XM23_190 vout net049 vss sub sg13_lv_nmos w=1u l=1u m=1
XT1707 vss sub ptap1 A=4e-12 P=8e-6
XM23_191 vout net049 vss sub sg13_lv_nmos w=1u l=1u m=1
XT1708 vss sub ptap1 A=4e-12 P=8e-6
XM23_192 vout net049 vss sub sg13_lv_nmos w=1u l=1u m=1
XT1709 vss sub ptap1 A=4e-12 P=8e-6
XM23_193 vout net049 vss sub sg13_lv_nmos w=1u l=1u m=1
XT1710 vss sub ptap1 A=4e-12 P=8e-6
XM23_194 vout net049 vss sub sg13_lv_nmos w=1u l=1u m=1
XT1711 vss sub ptap1 A=4e-12 P=8e-6
XM23_195 vout net049 vss sub sg13_lv_nmos w=1u l=1u m=1
XT1712 vss sub ptap1 A=4e-12 P=8e-6
XM23_196 vout net049 vss sub sg13_lv_nmos w=1u l=1u m=1
XT1713 vss sub ptap1 A=4e-12 P=8e-6
XM23_197 vout net049 vss sub sg13_lv_nmos w=1u l=1u m=1
XT1714 vss sub ptap1 A=4e-12 P=8e-6
XM23_198 vout net049 vss sub sg13_lv_nmos w=1u l=1u m=1
XT1715 vss sub ptap1 A=4e-12 P=8e-6
XM23_199 vout net049 vss sub sg13_lv_nmos w=1u l=1u m=1
XT1716 vss sub ptap1 A=4e-12 P=8e-6
XM23_200 vout net049 vss sub sg13_lv_nmos w=1u l=1u m=1
XT1717 vss sub ptap1 A=4e-12 P=8e-6
XM23_201 vout net049 vss sub sg13_lv_nmos w=1u l=1u m=1
XT1718 vss sub ptap1 A=4e-12 P=8e-6
XM23_202 vout net049 vss sub sg13_lv_nmos w=1u l=1u m=1
XT1719 vdd well_1719 ntap1 A=4e-12 P=8e-6
XM3_0 vb3 net1 vdd well_1719 sg13_lv_pmos w=1u l=1u m=1
XT1720 vdd well_1720 ntap1 A=4e-12 P=8e-6
XM3_1 vb3 net1 vdd well_1720 sg13_lv_pmos w=1u l=1u m=1
XT1721 vdd well_1721 ntap1 A=4e-12 P=8e-6
XM3_2 vb3 net1 vdd well_1721 sg13_lv_pmos w=1u l=1u m=1
XT1722 vdd well_1722 ntap1 A=4e-12 P=8e-6
XM3_3 vb3 net1 vdd well_1722 sg13_lv_pmos w=1u l=1u m=1
XT1723 vdd well_1723 ntap1 A=4e-12 P=8e-6
XM3_4 vb3 net1 vdd well_1723 sg13_lv_pmos w=1u l=1u m=1
XT1724 vdd well_1724 ntap1 A=4e-12 P=8e-6
XM3_5 vb3 net1 vdd well_1724 sg13_lv_pmos w=1u l=1u m=1
XT1725 vdd well_1725 ntap1 A=4e-12 P=8e-6
XM3_6 vb3 net1 vdd well_1725 sg13_lv_pmos w=1u l=1u m=1
XT1726 vdd well_1726 ntap1 A=4e-12 P=8e-6
XM3_7 vb3 net1 vdd well_1726 sg13_lv_pmos w=1u l=1u m=1
XT1727 vdd well_1727 ntap1 A=4e-12 P=8e-6
XM3_8 vb3 net1 vdd well_1727 sg13_lv_pmos w=1u l=1u m=1
XT1728 vdd well_1728 ntap1 A=4e-12 P=8e-6
XM3_9 vb3 net1 vdd well_1728 sg13_lv_pmos w=1u l=1u m=1
XT1729 vdd well_1729 ntap1 A=4e-12 P=8e-6
XM3_10 vb3 net1 vdd well_1729 sg13_lv_pmos w=1u l=1u m=1
XT1730 vdd well_1730 ntap1 A=4e-12 P=8e-6
XM3_11 vb3 net1 vdd well_1730 sg13_lv_pmos w=1u l=1u m=1
XT1731 vdd well_1731 ntap1 A=4e-12 P=8e-6
XM3_12 vb3 net1 vdd well_1731 sg13_lv_pmos w=1u l=1u m=1
XT1732 vdd well_1732 ntap1 A=4e-12 P=8e-6
XM3_13 vb3 net1 vdd well_1732 sg13_lv_pmos w=1u l=1u m=1
XT1733 vdd well_1733 ntap1 A=4e-12 P=8e-6
XM3_14 vb3 net1 vdd well_1733 sg13_lv_pmos w=1u l=1u m=1
XT1734 vdd well_1734 ntap1 A=4e-12 P=8e-6
XM3_15 vb3 net1 vdd well_1734 sg13_lv_pmos w=1u l=1u m=1
XT1735 vdd well_1735 ntap1 A=4e-12 P=8e-6
XM3_16 vb3 net1 vdd well_1735 sg13_lv_pmos w=1u l=1u m=1
XT1736 vdd well_1736 ntap1 A=4e-12 P=8e-6
XM3_17 vb3 net1 vdd well_1736 sg13_lv_pmos w=1u l=1u m=1
XT1737 vdd well_1737 ntap1 A=4e-12 P=8e-6
XM3_18 vb3 net1 vdd well_1737 sg13_lv_pmos w=1u l=1u m=1
XT1738 vdd well_1738 ntap1 A=4e-12 P=8e-6
XM3_19 vb3 net1 vdd well_1738 sg13_lv_pmos w=1u l=1u m=1
XT1739 vdd well_1739 ntap1 A=4e-12 P=8e-6
XM3_20 vb3 net1 vdd well_1739 sg13_lv_pmos w=1u l=1u m=1
XT1740 vdd well_1740 ntap1 A=4e-12 P=8e-6
XM3_21 vb3 net1 vdd well_1740 sg13_lv_pmos w=1u l=1u m=1
XT1741 vdd well_1741 ntap1 A=4e-12 P=8e-6
XM3_22 vb3 net1 vdd well_1741 sg13_lv_pmos w=1u l=1u m=1
XT1742 vdd well_1742 ntap1 A=4e-12 P=8e-6
XM3_23 vb3 net1 vdd well_1742 sg13_lv_pmos w=1u l=1u m=1
XT1743 vdd well_1743 ntap1 A=4e-12 P=8e-6
XM3_24 vb3 net1 vdd well_1743 sg13_lv_pmos w=1u l=1u m=1
XT1744 vdd well_1744 ntap1 A=4e-12 P=8e-6
XM3_25 vb3 net1 vdd well_1744 sg13_lv_pmos w=1u l=1u m=1
XT1745 vdd well_1745 ntap1 A=4e-12 P=8e-6
XM3_26 vb3 net1 vdd well_1745 sg13_lv_pmos w=1u l=1u m=1
XT1746 vdd well_1746 ntap1 A=4e-12 P=8e-6
XM3_27 vb3 net1 vdd well_1746 sg13_lv_pmos w=1u l=1u m=1
XT1747 vdd well_1747 ntap1 A=4e-12 P=8e-6
XM3_28 vb3 net1 vdd well_1747 sg13_lv_pmos w=1u l=1u m=1
XT1748 vdd well_1748 ntap1 A=4e-12 P=8e-6
XM3_29 vb3 net1 vdd well_1748 sg13_lv_pmos w=1u l=1u m=1
XT1749 vdd well_1749 ntap1 A=4e-12 P=8e-6
XM3_30 vb3 net1 vdd well_1749 sg13_lv_pmos w=1u l=1u m=1
XT1750 vdd well_1750 ntap1 A=4e-12 P=8e-6
XM3_31 vb3 net1 vdd well_1750 sg13_lv_pmos w=1u l=1u m=1
XT1751 vdd well_1751 ntap1 A=4e-12 P=8e-6
XM3_32 vb3 net1 vdd well_1751 sg13_lv_pmos w=1u l=1u m=1
XT1752 vdd well_1752 ntap1 A=4e-12 P=8e-6
XM3_33 vb3 net1 vdd well_1752 sg13_lv_pmos w=1u l=1u m=1
XT1753 vdd well_1753 ntap1 A=4e-12 P=8e-6
XM3_34 vb3 net1 vdd well_1753 sg13_lv_pmos w=1u l=1u m=1
XT1754 vdd well_1754 ntap1 A=4e-12 P=8e-6
XM3_35 vb3 net1 vdd well_1754 sg13_lv_pmos w=1u l=1u m=1
XT1755 vdd well_1755 ntap1 A=4e-12 P=8e-6
XM3_36 vb3 net1 vdd well_1755 sg13_lv_pmos w=1u l=1u m=1
XT1756 vdd well_1756 ntap1 A=4e-12 P=8e-6
XM3_37 vb3 net1 vdd well_1756 sg13_lv_pmos w=1u l=1u m=1
XT1757 vdd well_1757 ntap1 A=4e-12 P=8e-6
XM3_38 vb3 net1 vdd well_1757 sg13_lv_pmos w=1u l=1u m=1
XT1758 vdd well_1758 ntap1 A=4e-12 P=8e-6
XM3_39 vb3 net1 vdd well_1758 sg13_lv_pmos w=1u l=1u m=1
XT1759 vdd well_1759 ntap1 A=4e-12 P=8e-6
XM3_40 vb3 net1 vdd well_1759 sg13_lv_pmos w=1u l=1u m=1
XT1760 vdd well_1760 ntap1 A=4e-12 P=8e-6
XM3_41 vb3 net1 vdd well_1760 sg13_lv_pmos w=1u l=1u m=1
XT1761 vdd well_1761 ntap1 A=4e-12 P=8e-6
XM3_42 vb3 net1 vdd well_1761 sg13_lv_pmos w=1u l=1u m=1
XT1762 vdd well_1762 ntap1 A=4e-12 P=8e-6
XM3_43 vb3 net1 vdd well_1762 sg13_lv_pmos w=1u l=1u m=1
XT1763 vdd well_1763 ntap1 A=4e-12 P=8e-6
XM3_44 vb3 net1 vdd well_1763 sg13_lv_pmos w=1u l=1u m=1
XT1764 vdd well_1764 ntap1 A=4e-12 P=8e-6
XM3_45 vb3 net1 vdd well_1764 sg13_lv_pmos w=1u l=1u m=1
XT1765 vdd well_1765 ntap1 A=4e-12 P=8e-6
XM3_46 vb3 net1 vdd well_1765 sg13_lv_pmos w=1u l=1u m=1
XT1766 vdd well_1766 ntap1 A=4e-12 P=8e-6
XM3_47 vb3 net1 vdd well_1766 sg13_lv_pmos w=1u l=1u m=1
XT1767 vdd well_1767 ntap1 A=4e-12 P=8e-6
XM3_48 vb3 net1 vdd well_1767 sg13_lv_pmos w=1u l=1u m=1
XT1768 vdd well_1768 ntap1 A=4e-12 P=8e-6
XM3_49 vb3 net1 vdd well_1768 sg13_lv_pmos w=1u l=1u m=1
XT1769 vdd well_1769 ntap1 A=4e-12 P=8e-6
XM3_50 vb3 net1 vdd well_1769 sg13_lv_pmos w=1u l=1u m=1
XT1770 vdd well_1770 ntap1 A=4e-12 P=8e-6
XM3_51 vb3 net1 vdd well_1770 sg13_lv_pmos w=1u l=1u m=1
XT1771 vdd well_1771 ntap1 A=4e-12 P=8e-6
XM3_52 vb3 net1 vdd well_1771 sg13_lv_pmos w=1u l=1u m=1
XT1772 vdd well_1772 ntap1 A=4e-12 P=8e-6
XM3_53 vb3 net1 vdd well_1772 sg13_lv_pmos w=1u l=1u m=1
XT1773 vdd well_1773 ntap1 A=4e-12 P=8e-6
XM3_54 vb3 net1 vdd well_1773 sg13_lv_pmos w=1u l=1u m=1
XT1774 vdd well_1774 ntap1 A=4e-12 P=8e-6
XM3_55 vb3 net1 vdd well_1774 sg13_lv_pmos w=1u l=1u m=1
XT1775 vdd well_1775 ntap1 A=4e-12 P=8e-6
XM3_56 vb3 net1 vdd well_1775 sg13_lv_pmos w=1u l=1u m=1
XT1776 vdd well_1776 ntap1 A=4e-12 P=8e-6
XM3_57 vb3 net1 vdd well_1776 sg13_lv_pmos w=1u l=1u m=1
XT1777 vdd well_1777 ntap1 A=4e-12 P=8e-6
XM3_58 vb3 net1 vdd well_1777 sg13_lv_pmos w=1u l=1u m=1
XT1778 vdd well_1778 ntap1 A=4e-12 P=8e-6
XM3_59 vb3 net1 vdd well_1778 sg13_lv_pmos w=1u l=1u m=1
XT1779 vdd well_1779 ntap1 A=4e-12 P=8e-6
XM3_60 vb3 net1 vdd well_1779 sg13_lv_pmos w=1u l=1u m=1
XT1780 vdd well_1780 ntap1 A=4e-12 P=8e-6
XM3_61 vb3 net1 vdd well_1780 sg13_lv_pmos w=1u l=1u m=1
XT1781 vdd well_1781 ntap1 A=4e-12 P=8e-6
XM3_62 vb3 net1 vdd well_1781 sg13_lv_pmos w=1u l=1u m=1
XT1782 vdd well_1782 ntap1 A=4e-12 P=8e-6
XM3_63 vb3 net1 vdd well_1782 sg13_lv_pmos w=1u l=1u m=1
XT1783 vdd well_1783 ntap1 A=4e-12 P=8e-6
XM3_64 vb3 net1 vdd well_1783 sg13_lv_pmos w=1u l=1u m=1
XT1784 vdd well_1784 ntap1 A=4e-12 P=8e-6
XM3_65 vb3 net1 vdd well_1784 sg13_lv_pmos w=1u l=1u m=1
XT1785 vdd well_1785 ntap1 A=4e-12 P=8e-6
XM3_66 vb3 net1 vdd well_1785 sg13_lv_pmos w=1u l=1u m=1
XT1786 vdd well_1786 ntap1 A=4e-12 P=8e-6
XM3_67 vb3 net1 vdd well_1786 sg13_lv_pmos w=1u l=1u m=1
XT1787 vdd well_1787 ntap1 A=4e-12 P=8e-6
XM3_68 vb3 net1 vdd well_1787 sg13_lv_pmos w=1u l=1u m=1
XT1788 vdd well_1788 ntap1 A=4e-12 P=8e-6
XM3_69 vb3 net1 vdd well_1788 sg13_lv_pmos w=1u l=1u m=1
XT1789 vdd well_1789 ntap1 A=4e-12 P=8e-6
XM3_70 vb3 net1 vdd well_1789 sg13_lv_pmos w=1u l=1u m=1
XT1790 vdd well_1790 ntap1 A=4e-12 P=8e-6
XM4_0 net31 net1 vdd well_1790 sg13_lv_pmos w=1u l=1u m=1
XT1791 vdd well_1791 ntap1 A=4e-12 P=8e-6
XM4_1 net31 net1 vdd well_1791 sg13_lv_pmos w=1u l=1u m=1
XT1792 vdd well_1792 ntap1 A=4e-12 P=8e-6
XM4_2 net31 net1 vdd well_1792 sg13_lv_pmos w=1u l=1u m=1
XT1793 vdd well_1793 ntap1 A=4e-12 P=8e-6
XM4_3 net31 net1 vdd well_1793 sg13_lv_pmos w=1u l=1u m=1
XT1794 vdd well_1794 ntap1 A=4e-12 P=8e-6
XM4_4 net31 net1 vdd well_1794 sg13_lv_pmos w=1u l=1u m=1
XT1795 vdd well_1795 ntap1 A=4e-12 P=8e-6
XM4_5 net31 net1 vdd well_1795 sg13_lv_pmos w=1u l=1u m=1
XT1796 vdd well_1796 ntap1 A=4e-12 P=8e-6
XM4_6 net31 net1 vdd well_1796 sg13_lv_pmos w=1u l=1u m=1
XT1797 vdd well_1797 ntap1 A=4e-12 P=8e-6
XM4_7 net31 net1 vdd well_1797 sg13_lv_pmos w=1u l=1u m=1
XT1798 vdd well_1798 ntap1 A=4e-12 P=8e-6
XM4_8 net31 net1 vdd well_1798 sg13_lv_pmos w=1u l=1u m=1
XT1799 vdd well_1799 ntap1 A=4e-12 P=8e-6
XM4_9 net31 net1 vdd well_1799 sg13_lv_pmos w=1u l=1u m=1
XT1800 vdd well_1800 ntap1 A=4e-12 P=8e-6
XM4_10 net31 net1 vdd well_1800 sg13_lv_pmos w=1u l=1u m=1
XT1801 vdd well_1801 ntap1 A=4e-12 P=8e-6
XM4_11 net31 net1 vdd well_1801 sg13_lv_pmos w=1u l=1u m=1
XT1802 vdd well_1802 ntap1 A=4e-12 P=8e-6
XM4_12 net31 net1 vdd well_1802 sg13_lv_pmos w=1u l=1u m=1
XT1803 vdd well_1803 ntap1 A=4e-12 P=8e-6
XM4_13 net31 net1 vdd well_1803 sg13_lv_pmos w=1u l=1u m=1
XT1804 vdd well_1804 ntap1 A=4e-12 P=8e-6
XM4_14 net31 net1 vdd well_1804 sg13_lv_pmos w=1u l=1u m=1
XT1805 vdd well_1805 ntap1 A=4e-12 P=8e-6
XM4_15 net31 net1 vdd well_1805 sg13_lv_pmos w=1u l=1u m=1
XT1806 vdd well_1806 ntap1 A=4e-12 P=8e-6
XM4_16 net31 net1 vdd well_1806 sg13_lv_pmos w=1u l=1u m=1
XT1807 vdd well_1807 ntap1 A=4e-12 P=8e-6
XM4_17 net31 net1 vdd well_1807 sg13_lv_pmos w=1u l=1u m=1
XT1808 vdd well_1808 ntap1 A=4e-12 P=8e-6
XM4_18 net31 net1 vdd well_1808 sg13_lv_pmos w=1u l=1u m=1
XT1809 vdd well_1809 ntap1 A=4e-12 P=8e-6
XM4_19 net31 net1 vdd well_1809 sg13_lv_pmos w=1u l=1u m=1
XT1810 vdd well_1810 ntap1 A=4e-12 P=8e-6
XM4_20 net31 net1 vdd well_1810 sg13_lv_pmos w=1u l=1u m=1
XT1811 vdd well_1811 ntap1 A=4e-12 P=8e-6
XM4_21 net31 net1 vdd well_1811 sg13_lv_pmos w=1u l=1u m=1
XT1812 vdd well_1812 ntap1 A=4e-12 P=8e-6
XM4_22 net31 net1 vdd well_1812 sg13_lv_pmos w=1u l=1u m=1
XT1813 vdd well_1813 ntap1 A=4e-12 P=8e-6
XM4_23 net31 net1 vdd well_1813 sg13_lv_pmos w=1u l=1u m=1
XT1814 vdd well_1814 ntap1 A=4e-12 P=8e-6
XM4_24 net31 net1 vdd well_1814 sg13_lv_pmos w=1u l=1u m=1
XT1815 vdd well_1815 ntap1 A=4e-12 P=8e-6
XM4_25 net31 net1 vdd well_1815 sg13_lv_pmos w=1u l=1u m=1
XT1816 vdd well_1816 ntap1 A=4e-12 P=8e-6
XM4_26 net31 net1 vdd well_1816 sg13_lv_pmos w=1u l=1u m=1
XT1817 vdd well_1817 ntap1 A=4e-12 P=8e-6
XM4_27 net31 net1 vdd well_1817 sg13_lv_pmos w=1u l=1u m=1
XT1818 vdd well_1818 ntap1 A=4e-12 P=8e-6
XM4_28 net31 net1 vdd well_1818 sg13_lv_pmos w=1u l=1u m=1
XT1819 vdd well_1819 ntap1 A=4e-12 P=8e-6
XM4_29 net31 net1 vdd well_1819 sg13_lv_pmos w=1u l=1u m=1
XT1820 vdd well_1820 ntap1 A=4e-12 P=8e-6
XM4_30 net31 net1 vdd well_1820 sg13_lv_pmos w=1u l=1u m=1
XT1821 vdd well_1821 ntap1 A=4e-12 P=8e-6
XM4_31 net31 net1 vdd well_1821 sg13_lv_pmos w=1u l=1u m=1
XT1822 vdd well_1822 ntap1 A=4e-12 P=8e-6
XM4_32 net31 net1 vdd well_1822 sg13_lv_pmos w=1u l=1u m=1
XT1823 vdd well_1823 ntap1 A=4e-12 P=8e-6
XM4_33 net31 net1 vdd well_1823 sg13_lv_pmos w=1u l=1u m=1
XT1824 vdd well_1824 ntap1 A=4e-12 P=8e-6
XM4_34 net31 net1 vdd well_1824 sg13_lv_pmos w=1u l=1u m=1
XT1825 vdd well_1825 ntap1 A=4e-12 P=8e-6
XM4_35 net31 net1 vdd well_1825 sg13_lv_pmos w=1u l=1u m=1
XT1826 vdd well_1826 ntap1 A=4e-12 P=8e-6
XM4_36 net31 net1 vdd well_1826 sg13_lv_pmos w=1u l=1u m=1
XT1827 vdd well_1827 ntap1 A=4e-12 P=8e-6
XM4_37 net31 net1 vdd well_1827 sg13_lv_pmos w=1u l=1u m=1
XT1828 vdd well_1828 ntap1 A=4e-12 P=8e-6
XM4_38 net31 net1 vdd well_1828 sg13_lv_pmos w=1u l=1u m=1
XT1829 vdd well_1829 ntap1 A=4e-12 P=8e-6
XM4_39 net31 net1 vdd well_1829 sg13_lv_pmos w=1u l=1u m=1
XT1830 vdd well_1830 ntap1 A=4e-12 P=8e-6
XM4_40 net31 net1 vdd well_1830 sg13_lv_pmos w=1u l=1u m=1
XT1831 vdd well_1831 ntap1 A=4e-12 P=8e-6
XM4_41 net31 net1 vdd well_1831 sg13_lv_pmos w=1u l=1u m=1
XT1832 vdd well_1832 ntap1 A=4e-12 P=8e-6
XM4_42 net31 net1 vdd well_1832 sg13_lv_pmos w=1u l=1u m=1
XT1833 vdd well_1833 ntap1 A=4e-12 P=8e-6
XM4_43 net31 net1 vdd well_1833 sg13_lv_pmos w=1u l=1u m=1
XT1834 vdd well_1834 ntap1 A=4e-12 P=8e-6
XM4_44 net31 net1 vdd well_1834 sg13_lv_pmos w=1u l=1u m=1
XT1835 vdd well_1835 ntap1 A=4e-12 P=8e-6
XM4_45 net31 net1 vdd well_1835 sg13_lv_pmos w=1u l=1u m=1
XT1836 vdd well_1836 ntap1 A=4e-12 P=8e-6
XM4_46 net31 net1 vdd well_1836 sg13_lv_pmos w=1u l=1u m=1
XT1837 vdd well_1837 ntap1 A=4e-12 P=8e-6
XM4_47 net31 net1 vdd well_1837 sg13_lv_pmos w=1u l=1u m=1
XT1838 vdd well_1838 ntap1 A=4e-12 P=8e-6
XM4_48 net31 net1 vdd well_1838 sg13_lv_pmos w=1u l=1u m=1
XT1839 vdd well_1839 ntap1 A=4e-12 P=8e-6
XM4_49 net31 net1 vdd well_1839 sg13_lv_pmos w=1u l=1u m=1
XT1840 vdd well_1840 ntap1 A=4e-12 P=8e-6
XM4_50 net31 net1 vdd well_1840 sg13_lv_pmos w=1u l=1u m=1
XT1841 vdd well_1841 ntap1 A=4e-12 P=8e-6
XM4_51 net31 net1 vdd well_1841 sg13_lv_pmos w=1u l=1u m=1
XT1842 vdd well_1842 ntap1 A=4e-12 P=8e-6
XM4_52 net31 net1 vdd well_1842 sg13_lv_pmos w=1u l=1u m=1
XT1843 vdd well_1843 ntap1 A=4e-12 P=8e-6
XM4_53 net31 net1 vdd well_1843 sg13_lv_pmos w=1u l=1u m=1
XT1844 vdd well_1844 ntap1 A=4e-12 P=8e-6
XM4_54 net31 net1 vdd well_1844 sg13_lv_pmos w=1u l=1u m=1
XT1845 vdd well_1845 ntap1 A=4e-12 P=8e-6
XM4_55 net31 net1 vdd well_1845 sg13_lv_pmos w=1u l=1u m=1
XT1846 vdd well_1846 ntap1 A=4e-12 P=8e-6
XM4_56 net31 net1 vdd well_1846 sg13_lv_pmos w=1u l=1u m=1
XT1847 vdd well_1847 ntap1 A=4e-12 P=8e-6
XM4_57 net31 net1 vdd well_1847 sg13_lv_pmos w=1u l=1u m=1
XT1848 vdd well_1848 ntap1 A=4e-12 P=8e-6
XM4_58 net31 net1 vdd well_1848 sg13_lv_pmos w=1u l=1u m=1
XT1849 vdd well_1849 ntap1 A=4e-12 P=8e-6
XM4_59 net31 net1 vdd well_1849 sg13_lv_pmos w=1u l=1u m=1
XT1850 vdd well_1850 ntap1 A=4e-12 P=8e-6
XM4_60 net31 net1 vdd well_1850 sg13_lv_pmos w=1u l=1u m=1
XT1851 vdd well_1851 ntap1 A=4e-12 P=8e-6
XM4_61 net31 net1 vdd well_1851 sg13_lv_pmos w=1u l=1u m=1
XT1852 vdd well_1852 ntap1 A=4e-12 P=8e-6
XM4_62 net31 net1 vdd well_1852 sg13_lv_pmos w=1u l=1u m=1
XT1853 vdd well_1853 ntap1 A=4e-12 P=8e-6
XM4_63 net31 net1 vdd well_1853 sg13_lv_pmos w=1u l=1u m=1
XT1854 vdd well_1854 ntap1 A=4e-12 P=8e-6
XM4_64 net31 net1 vdd well_1854 sg13_lv_pmos w=1u l=1u m=1
XT1855 vdd well_1855 ntap1 A=4e-12 P=8e-6
XM4_65 net31 net1 vdd well_1855 sg13_lv_pmos w=1u l=1u m=1
XT1856 vdd well_1856 ntap1 A=4e-12 P=8e-6
XM4_66 net31 net1 vdd well_1856 sg13_lv_pmos w=1u l=1u m=1
XT1857 vdd well_1857 ntap1 A=4e-12 P=8e-6
XM4_67 net31 net1 vdd well_1857 sg13_lv_pmos w=1u l=1u m=1
XT1858 vdd well_1858 ntap1 A=4e-12 P=8e-6
XM4_68 net31 net1 vdd well_1858 sg13_lv_pmos w=1u l=1u m=1
XT1859 vdd well_1859 ntap1 A=4e-12 P=8e-6
XM4_69 net31 net1 vdd well_1859 sg13_lv_pmos w=1u l=1u m=1
XT1860 vdd well_1860 ntap1 A=4e-12 P=8e-6
XM4_70 net31 net1 vdd well_1860 sg13_lv_pmos w=1u l=1u m=1
XT1861 vdd well_1861 ntap1 A=4e-12 P=8e-6
XM4_71 net31 net1 vdd well_1861 sg13_lv_pmos w=1u l=1u m=1
XT1862 vdd well_1862 ntap1 A=4e-12 P=8e-6
XM4_72 net31 net1 vdd well_1862 sg13_lv_pmos w=1u l=1u m=1
XT1863 vdd well_1863 ntap1 A=4e-12 P=8e-6
XM4_73 net31 net1 vdd well_1863 sg13_lv_pmos w=1u l=1u m=1
XT1864 vdd well_1864 ntap1 A=4e-12 P=8e-6
XM4_74 net31 net1 vdd well_1864 sg13_lv_pmos w=1u l=1u m=1
XT1865 vdd well_1865 ntap1 A=4e-12 P=8e-6
XM4_75 net31 net1 vdd well_1865 sg13_lv_pmos w=1u l=1u m=1
XT1866 vdd well_1866 ntap1 A=4e-12 P=8e-6
XM4_76 net31 net1 vdd well_1866 sg13_lv_pmos w=1u l=1u m=1
XT1867 vdd well_1867 ntap1 A=4e-12 P=8e-6
XM4_77 net31 net1 vdd well_1867 sg13_lv_pmos w=1u l=1u m=1
XT1868 vdd well_1868 ntap1 A=4e-12 P=8e-6
XM4_78 net31 net1 vdd well_1868 sg13_lv_pmos w=1u l=1u m=1
XT1869 vdd well_1869 ntap1 A=4e-12 P=8e-6
XM4_79 net31 net1 vdd well_1869 sg13_lv_pmos w=1u l=1u m=1
XT1870 vdd well_1870 ntap1 A=4e-12 P=8e-6
XM4_80 net31 net1 vdd well_1870 sg13_lv_pmos w=1u l=1u m=1
XT1871 vdd well_1871 ntap1 A=4e-12 P=8e-6
XM4_81 net31 net1 vdd well_1871 sg13_lv_pmos w=1u l=1u m=1
XT1872 vdd well_1872 ntap1 A=4e-12 P=8e-6
XM4_82 net31 net1 vdd well_1872 sg13_lv_pmos w=1u l=1u m=1
XT1873 vdd well_1873 ntap1 A=4e-12 P=8e-6
XM4_83 net31 net1 vdd well_1873 sg13_lv_pmos w=1u l=1u m=1
XT1874 vdd well_1874 ntap1 A=4e-12 P=8e-6
XM4_84 net31 net1 vdd well_1874 sg13_lv_pmos w=1u l=1u m=1
XT1875 vdd well_1875 ntap1 A=4e-12 P=8e-6
XM4_85 net31 net1 vdd well_1875 sg13_lv_pmos w=1u l=1u m=1
XT1876 vdd well_1876 ntap1 A=4e-12 P=8e-6
XM4_86 net31 net1 vdd well_1876 sg13_lv_pmos w=1u l=1u m=1
XT1877 vdd well_1877 ntap1 A=4e-12 P=8e-6
XM4_87 net31 net1 vdd well_1877 sg13_lv_pmos w=1u l=1u m=1
XT1878 vdd well_1878 ntap1 A=4e-12 P=8e-6
XM4_88 net31 net1 vdd well_1878 sg13_lv_pmos w=1u l=1u m=1
XT1879 vdd well_1879 ntap1 A=4e-12 P=8e-6
XM4_89 net31 net1 vdd well_1879 sg13_lv_pmos w=1u l=1u m=1
XT1880 vdd well_1880 ntap1 A=4e-12 P=8e-6
XM4_90 net31 net1 vdd well_1880 sg13_lv_pmos w=1u l=1u m=1
XT1881 vdd well_1881 ntap1 A=4e-12 P=8e-6
XM4_91 net31 net1 vdd well_1881 sg13_lv_pmos w=1u l=1u m=1
XT1882 vdd well_1882 ntap1 A=4e-12 P=8e-6
XM4_92 net31 net1 vdd well_1882 sg13_lv_pmos w=1u l=1u m=1
XT1883 vdd well_1883 ntap1 A=4e-12 P=8e-6
XM4_93 net31 net1 vdd well_1883 sg13_lv_pmos w=1u l=1u m=1
XT1884 vdd well_1884 ntap1 A=4e-12 P=8e-6
XM4_94 net31 net1 vdd well_1884 sg13_lv_pmos w=1u l=1u m=1
XT1885 vdd well_1885 ntap1 A=4e-12 P=8e-6
XM4_95 net31 net1 vdd well_1885 sg13_lv_pmos w=1u l=1u m=1
XT1886 vdd well_1886 ntap1 A=4e-12 P=8e-6
XM4_96 net31 net1 vdd well_1886 sg13_lv_pmos w=1u l=1u m=1
XT1887 vdd well_1887 ntap1 A=4e-12 P=8e-6
XM4_97 net31 net1 vdd well_1887 sg13_lv_pmos w=1u l=1u m=1
XT1888 vdd well_1888 ntap1 A=4e-12 P=8e-6
XM4_98 net31 net1 vdd well_1888 sg13_lv_pmos w=1u l=1u m=1
XT1889 vdd well_1889 ntap1 A=4e-12 P=8e-6
XM4_99 net31 net1 vdd well_1889 sg13_lv_pmos w=1u l=1u m=1
XT1890 vdd well_1890 ntap1 A=4e-12 P=8e-6
XM4_100 net31 net1 vdd well_1890 sg13_lv_pmos w=1u l=1u m=1
XT1891 vdd well_1891 ntap1 A=4e-12 P=8e-6
XM4_101 net31 net1 vdd well_1891 sg13_lv_pmos w=1u l=1u m=1
XT1892 vdd well_1892 ntap1 A=4e-12 P=8e-6
XM4_102 net31 net1 vdd well_1892 sg13_lv_pmos w=1u l=1u m=1
XT1893 vdd well_1893 ntap1 A=4e-12 P=8e-6
XM4_103 net31 net1 vdd well_1893 sg13_lv_pmos w=1u l=1u m=1
XT1894 vdd well_1894 ntap1 A=4e-12 P=8e-6
XM4_104 net31 net1 vdd well_1894 sg13_lv_pmos w=1u l=1u m=1
XT1895 vdd well_1895 ntap1 A=4e-12 P=8e-6
XM4_105 net31 net1 vdd well_1895 sg13_lv_pmos w=1u l=1u m=1
XT1896 vdd well_1896 ntap1 A=4e-12 P=8e-6
XM4_106 net31 net1 vdd well_1896 sg13_lv_pmos w=1u l=1u m=1
XT1897 vdd well_1897 ntap1 A=4e-12 P=8e-6
XM4_107 net31 net1 vdd well_1897 sg13_lv_pmos w=1u l=1u m=1
XT1898 vdd well_1898 ntap1 A=4e-12 P=8e-6
XM4_108 net31 net1 vdd well_1898 sg13_lv_pmos w=1u l=1u m=1
XT1899 vdd well_1899 ntap1 A=4e-12 P=8e-6
XM4_109 net31 net1 vdd well_1899 sg13_lv_pmos w=1u l=1u m=1
XT1900 vdd well_1900 ntap1 A=4e-12 P=8e-6
XM4_110 net31 net1 vdd well_1900 sg13_lv_pmos w=1u l=1u m=1
XT1901 vdd well_1901 ntap1 A=4e-12 P=8e-6
XM4_111 net31 net1 vdd well_1901 sg13_lv_pmos w=1u l=1u m=1
XT1902 vdd well_1902 ntap1 A=4e-12 P=8e-6
XM4_112 net31 net1 vdd well_1902 sg13_lv_pmos w=1u l=1u m=1
XT1903 vdd well_1903 ntap1 A=4e-12 P=8e-6
XM4_113 net31 net1 vdd well_1903 sg13_lv_pmos w=1u l=1u m=1
XT1904 vdd well_1904 ntap1 A=4e-12 P=8e-6
XM4_114 net31 net1 vdd well_1904 sg13_lv_pmos w=1u l=1u m=1
XT1905 vdd well_1905 ntap1 A=4e-12 P=8e-6
XM4_115 net31 net1 vdd well_1905 sg13_lv_pmos w=1u l=1u m=1
XT1906 vdd well_1906 ntap1 A=4e-12 P=8e-6
XM4_116 net31 net1 vdd well_1906 sg13_lv_pmos w=1u l=1u m=1
XT1907 vdd well_1907 ntap1 A=4e-12 P=8e-6
XM4_117 net31 net1 vdd well_1907 sg13_lv_pmos w=1u l=1u m=1
XT1908 vdd well_1908 ntap1 A=4e-12 P=8e-6
XM4_118 net31 net1 vdd well_1908 sg13_lv_pmos w=1u l=1u m=1
XT1909 vdd well_1909 ntap1 A=4e-12 P=8e-6
XM4_119 net31 net1 vdd well_1909 sg13_lv_pmos w=1u l=1u m=1
XT1910 vdd well_1910 ntap1 A=4e-12 P=8e-6
XM4_120 net31 net1 vdd well_1910 sg13_lv_pmos w=1u l=1u m=1
XT1911 vdd well_1911 ntap1 A=4e-12 P=8e-6
XM4_121 net31 net1 vdd well_1911 sg13_lv_pmos w=1u l=1u m=1
XT1912 vdd well_1912 ntap1 A=4e-12 P=8e-6
XM4_122 net31 net1 vdd well_1912 sg13_lv_pmos w=1u l=1u m=1
XT1913 vdd well_1913 ntap1 A=4e-12 P=8e-6
XM4_123 net31 net1 vdd well_1913 sg13_lv_pmos w=1u l=1u m=1
XT1914 vdd well_1914 ntap1 A=4e-12 P=8e-6
XM4_124 net31 net1 vdd well_1914 sg13_lv_pmos w=1u l=1u m=1
XT1915 vdd well_1915 ntap1 A=4e-12 P=8e-6
XM4_125 net31 net1 vdd well_1915 sg13_lv_pmos w=1u l=1u m=1
XT1916 vdd well_1916 ntap1 A=4e-12 P=8e-6
XM4_126 net31 net1 vdd well_1916 sg13_lv_pmos w=1u l=1u m=1
XT1917 vdd well_1917 ntap1 A=4e-12 P=8e-6
XM4_127 net31 net1 vdd well_1917 sg13_lv_pmos w=1u l=1u m=1
XT1918 vdd well_1918 ntap1 A=4e-12 P=8e-6
XM4_128 net31 net1 vdd well_1918 sg13_lv_pmos w=1u l=1u m=1
XT1919 vdd well_1919 ntap1 A=4e-12 P=8e-6
XM4_129 net31 net1 vdd well_1919 sg13_lv_pmos w=1u l=1u m=1
XT1920 vdd well_1920 ntap1 A=4e-12 P=8e-6
XM4_130 net31 net1 vdd well_1920 sg13_lv_pmos w=1u l=1u m=1
XT1921 vdd well_1921 ntap1 A=4e-12 P=8e-6
XM4_131 net31 net1 vdd well_1921 sg13_lv_pmos w=1u l=1u m=1
XT1922 vdd well_1922 ntap1 A=4e-12 P=8e-6
XM4_132 net31 net1 vdd well_1922 sg13_lv_pmos w=1u l=1u m=1
XT1923 vdd well_1923 ntap1 A=4e-12 P=8e-6
XM4_133 net31 net1 vdd well_1923 sg13_lv_pmos w=1u l=1u m=1
XT1924 vdd well_1924 ntap1 A=4e-12 P=8e-6
XM4_134 net31 net1 vdd well_1924 sg13_lv_pmos w=1u l=1u m=1
XT1925 vdd well_1925 ntap1 A=4e-12 P=8e-6
XM4_135 net31 net1 vdd well_1925 sg13_lv_pmos w=1u l=1u m=1
XT1926 vdd well_1926 ntap1 A=4e-12 P=8e-6
XM4_136 net31 net1 vdd well_1926 sg13_lv_pmos w=1u l=1u m=1
XT1927 vdd well_1927 ntap1 A=4e-12 P=8e-6
XM4_137 net31 net1 vdd well_1927 sg13_lv_pmos w=1u l=1u m=1
XT1928 vdd well_1928 ntap1 A=4e-12 P=8e-6
XM4_138 net31 net1 vdd well_1928 sg13_lv_pmos w=1u l=1u m=1
XT1929 vdd well_1929 ntap1 A=4e-12 P=8e-6
XM4_139 net31 net1 vdd well_1929 sg13_lv_pmos w=1u l=1u m=1
XT1930 vdd well_1930 ntap1 A=4e-12 P=8e-6
XM4_140 net31 net1 vdd well_1930 sg13_lv_pmos w=1u l=1u m=1
XT1931 vdd well_1931 ntap1 A=4e-12 P=8e-6
XM4_141 net31 net1 vdd well_1931 sg13_lv_pmos w=1u l=1u m=1
XT1932 vdd well_1932 ntap1 A=4e-12 P=8e-6
XM4_142 net31 net1 vdd well_1932 sg13_lv_pmos w=1u l=1u m=1
XT1933 vdd well_1933 ntap1 A=4e-12 P=8e-6
XM4_143 net31 net1 vdd well_1933 sg13_lv_pmos w=1u l=1u m=1
XT1934 vdd well_1934 ntap1 A=4e-12 P=8e-6
XM4_144 net31 net1 vdd well_1934 sg13_lv_pmos w=1u l=1u m=1
XT1935 vdd well_1935 ntap1 A=4e-12 P=8e-6
XM4_145 net31 net1 vdd well_1935 sg13_lv_pmos w=1u l=1u m=1
XT1936 vdd well_1936 ntap1 A=4e-12 P=8e-6
XM4_146 net31 net1 vdd well_1936 sg13_lv_pmos w=1u l=1u m=1
XT1937 vdd well_1937 ntap1 A=4e-12 P=8e-6
XM4_147 net31 net1 vdd well_1937 sg13_lv_pmos w=1u l=1u m=1
XT1938 vdd well_1938 ntap1 A=4e-12 P=8e-6
XM4_148 net31 net1 vdd well_1938 sg13_lv_pmos w=1u l=1u m=1
XT1939 vdd well_1939 ntap1 A=4e-12 P=8e-6
XM4_149 net31 net1 vdd well_1939 sg13_lv_pmos w=1u l=1u m=1
XT1940 vdd well_1940 ntap1 A=4e-12 P=8e-6
XM4_150 net31 net1 vdd well_1940 sg13_lv_pmos w=1u l=1u m=1
XT1941 vdd well_1941 ntap1 A=4e-12 P=8e-6
XM4_151 net31 net1 vdd well_1941 sg13_lv_pmos w=1u l=1u m=1
XT1942 vdd well_1942 ntap1 A=4e-12 P=8e-6
XM4_152 net31 net1 vdd well_1942 sg13_lv_pmos w=1u l=1u m=1
XT1943 vdd well_1943 ntap1 A=4e-12 P=8e-6
XM4_153 net31 net1 vdd well_1943 sg13_lv_pmos w=1u l=1u m=1
XT1944 vdd well_1944 ntap1 A=4e-12 P=8e-6
XM4_154 net31 net1 vdd well_1944 sg13_lv_pmos w=1u l=1u m=1
XT1945 vdd well_1945 ntap1 A=4e-12 P=8e-6
XM4_155 net31 net1 vdd well_1945 sg13_lv_pmos w=1u l=1u m=1
XT1946 vdd well_1946 ntap1 A=4e-12 P=8e-6
XM4_156 net31 net1 vdd well_1946 sg13_lv_pmos w=1u l=1u m=1
XT1947 vdd well_1947 ntap1 A=4e-12 P=8e-6
XM4_157 net31 net1 vdd well_1947 sg13_lv_pmos w=1u l=1u m=1
XT1948 vdd well_1948 ntap1 A=4e-12 P=8e-6
XM4_158 net31 net1 vdd well_1948 sg13_lv_pmos w=1u l=1u m=1
XT1949 vdd well_1949 ntap1 A=4e-12 P=8e-6
XM4_159 net31 net1 vdd well_1949 sg13_lv_pmos w=1u l=1u m=1
XT1950 vdd well_1950 ntap1 A=4e-12 P=8e-6
XM4_160 net31 net1 vdd well_1950 sg13_lv_pmos w=1u l=1u m=1
XT1951 vdd well_1951 ntap1 A=4e-12 P=8e-6
XM4_161 net31 net1 vdd well_1951 sg13_lv_pmos w=1u l=1u m=1
XT1952 vdd well_1952 ntap1 A=4e-12 P=8e-6
XM4_162 net31 net1 vdd well_1952 sg13_lv_pmos w=1u l=1u m=1
XT1953 vdd well_1953 ntap1 A=4e-12 P=8e-6
XM4_163 net31 net1 vdd well_1953 sg13_lv_pmos w=1u l=1u m=1
XT1954 vdd well_1954 ntap1 A=4e-12 P=8e-6
XM4_164 net31 net1 vdd well_1954 sg13_lv_pmos w=1u l=1u m=1
XT1955 vdd well_1955 ntap1 A=4e-12 P=8e-6
XM4_165 net31 net1 vdd well_1955 sg13_lv_pmos w=1u l=1u m=1
XT1956 vdd well_1956 ntap1 A=4e-12 P=8e-6
XM4_166 net31 net1 vdd well_1956 sg13_lv_pmos w=1u l=1u m=1
XT1957 vdd well_1957 ntap1 A=4e-12 P=8e-6
XM4_167 net31 net1 vdd well_1957 sg13_lv_pmos w=1u l=1u m=1
XT1958 vdd well_1958 ntap1 A=4e-12 P=8e-6
XM4_168 net31 net1 vdd well_1958 sg13_lv_pmos w=1u l=1u m=1
XT1959 vdd well_1959 ntap1 A=4e-12 P=8e-6
XM4_169 net31 net1 vdd well_1959 sg13_lv_pmos w=1u l=1u m=1
XT1960 vdd well_1960 ntap1 A=4e-12 P=8e-6
XM4_170 net31 net1 vdd well_1960 sg13_lv_pmos w=1u l=1u m=1
XT1961 vdd well_1961 ntap1 A=4e-12 P=8e-6
XM4_171 net31 net1 vdd well_1961 sg13_lv_pmos w=1u l=1u m=1
XT1962 vdd well_1962 ntap1 A=4e-12 P=8e-6
XM4_172 net31 net1 vdd well_1962 sg13_lv_pmos w=1u l=1u m=1
XT1963 vdd well_1963 ntap1 A=4e-12 P=8e-6
XM4_173 net31 net1 vdd well_1963 sg13_lv_pmos w=1u l=1u m=1
XT1964 vdd well_1964 ntap1 A=4e-12 P=8e-6
XM4_174 net31 net1 vdd well_1964 sg13_lv_pmos w=1u l=1u m=1
XT1965 vdd well_1965 ntap1 A=4e-12 P=8e-6
XM4_175 net31 net1 vdd well_1965 sg13_lv_pmos w=1u l=1u m=1
XT1966 vdd well_1966 ntap1 A=4e-12 P=8e-6
XM4_176 net31 net1 vdd well_1966 sg13_lv_pmos w=1u l=1u m=1
XT1967 vdd well_1967 ntap1 A=4e-12 P=8e-6
XM4_177 net31 net1 vdd well_1967 sg13_lv_pmos w=1u l=1u m=1
XT1968 vdd well_1968 ntap1 A=4e-12 P=8e-6
XM4_178 net31 net1 vdd well_1968 sg13_lv_pmos w=1u l=1u m=1
XT1969 vdd well_1969 ntap1 A=4e-12 P=8e-6
XM4_179 net31 net1 vdd well_1969 sg13_lv_pmos w=1u l=1u m=1
XT1970 vdd well_1970 ntap1 A=4e-12 P=8e-6
XM4_180 net31 net1 vdd well_1970 sg13_lv_pmos w=1u l=1u m=1
XT1971 vdd well_1971 ntap1 A=4e-12 P=8e-6
XM4_181 net31 net1 vdd well_1971 sg13_lv_pmos w=1u l=1u m=1
XT1972 vdd well_1972 ntap1 A=4e-12 P=8e-6
XM4_182 net31 net1 vdd well_1972 sg13_lv_pmos w=1u l=1u m=1
XT1973 vdd well_1973 ntap1 A=4e-12 P=8e-6
XM4_183 net31 net1 vdd well_1973 sg13_lv_pmos w=1u l=1u m=1
XT1974 vdd well_1974 ntap1 A=4e-12 P=8e-6
XM4_184 net31 net1 vdd well_1974 sg13_lv_pmos w=1u l=1u m=1
XT1975 vdd well_1975 ntap1 A=4e-12 P=8e-6
XM4_185 net31 net1 vdd well_1975 sg13_lv_pmos w=1u l=1u m=1
XT1976 vdd well_1976 ntap1 A=4e-12 P=8e-6
XM4_186 net31 net1 vdd well_1976 sg13_lv_pmos w=1u l=1u m=1
XT1977 vdd well_1977 ntap1 A=4e-12 P=8e-6
XM4_187 net31 net1 vdd well_1977 sg13_lv_pmos w=1u l=1u m=1
XT1978 vdd well_1978 ntap1 A=4e-12 P=8e-6
XM4_188 net31 net1 vdd well_1978 sg13_lv_pmos w=1u l=1u m=1
XT1979 vdd well_1979 ntap1 A=4e-12 P=8e-6
XM4_189 net31 net1 vdd well_1979 sg13_lv_pmos w=1u l=1u m=1
XT1980 vdd well_1980 ntap1 A=4e-12 P=8e-6
XM4_190 net31 net1 vdd well_1980 sg13_lv_pmos w=1u l=1u m=1
XT1981 vdd well_1981 ntap1 A=4e-12 P=8e-6
XM4_191 net31 net1 vdd well_1981 sg13_lv_pmos w=1u l=1u m=1
XT1982 vdd well_1982 ntap1 A=4e-12 P=8e-6
XM4_192 net31 net1 vdd well_1982 sg13_lv_pmos w=1u l=1u m=1
XT1983 vdd well_1983 ntap1 A=4e-12 P=8e-6
XM4_193 net31 net1 vdd well_1983 sg13_lv_pmos w=1u l=1u m=1
XT1984 vdd well_1984 ntap1 A=4e-12 P=8e-6
XM4_194 net31 net1 vdd well_1984 sg13_lv_pmos w=1u l=1u m=1
XT1985 vdd well_1985 ntap1 A=4e-12 P=8e-6
XM4_195 net31 net1 vdd well_1985 sg13_lv_pmos w=1u l=1u m=1
XT1986 vdd well_1986 ntap1 A=4e-12 P=8e-6
XM4_196 net31 net1 vdd well_1986 sg13_lv_pmos w=1u l=1u m=1
XT1987 vdd well_1987 ntap1 A=4e-12 P=8e-6
XM4_197 net31 net1 vdd well_1987 sg13_lv_pmos w=1u l=1u m=1
XT1988 vdd well_1988 ntap1 A=4e-12 P=8e-6
XM4_198 net31 net1 vdd well_1988 sg13_lv_pmos w=1u l=1u m=1
XT1989 vdd well_1989 ntap1 A=4e-12 P=8e-6
XM4_199 net31 net1 vdd well_1989 sg13_lv_pmos w=1u l=1u m=1
XT1990 vdd well_1990 ntap1 A=4e-12 P=8e-6
XM4_200 net31 net1 vdd well_1990 sg13_lv_pmos w=1u l=1u m=1
XT1991 vdd well_1991 ntap1 A=4e-12 P=8e-6
XM4_201 net31 net1 vdd well_1991 sg13_lv_pmos w=1u l=1u m=1
XT1992 vdd well_1992 ntap1 A=4e-12 P=8e-6
XM4_202 net31 net1 vdd well_1992 sg13_lv_pmos w=1u l=1u m=1
XT1993 vdd well_1993 ntap1 A=4e-12 P=8e-6
XM4_203 net31 net1 vdd well_1993 sg13_lv_pmos w=1u l=1u m=1
XT1994 vdd well_1994 ntap1 A=4e-12 P=8e-6
XM4_204 net31 net1 vdd well_1994 sg13_lv_pmos w=1u l=1u m=1
XT1995 vdd well_1995 ntap1 A=4e-12 P=8e-6
XM4_205 net31 net1 vdd well_1995 sg13_lv_pmos w=1u l=1u m=1
XT1996 vdd well_1996 ntap1 A=4e-12 P=8e-6
XM4_206 net31 net1 vdd well_1996 sg13_lv_pmos w=1u l=1u m=1
XT1997 vdd well_1997 ntap1 A=4e-12 P=8e-6
XM4_207 net31 net1 vdd well_1997 sg13_lv_pmos w=1u l=1u m=1
XT1998 vdd well_1998 ntap1 A=4e-12 P=8e-6
XM4_208 net31 net1 vdd well_1998 sg13_lv_pmos w=1u l=1u m=1
XT1999 vdd well_1999 ntap1 A=4e-12 P=8e-6
XM4_209 net31 net1 vdd well_1999 sg13_lv_pmos w=1u l=1u m=1
XT2000 vdd well_2000 ntap1 A=4e-12 P=8e-6
XM4_210 net31 net1 vdd well_2000 sg13_lv_pmos w=1u l=1u m=1
XT2001 vdd well_2001 ntap1 A=4e-12 P=8e-6
XM4_211 net31 net1 vdd well_2001 sg13_lv_pmos w=1u l=1u m=1
XT2002 vdd well_2002 ntap1 A=4e-12 P=8e-6
XM4_212 net31 net1 vdd well_2002 sg13_lv_pmos w=1u l=1u m=1
XT2003 vdd well_2003 ntap1 A=4e-12 P=8e-6
XM4_213 net31 net1 vdd well_2003 sg13_lv_pmos w=1u l=1u m=1
XT2004 vdd well_2004 ntap1 A=4e-12 P=8e-6
XM4_214 net31 net1 vdd well_2004 sg13_lv_pmos w=1u l=1u m=1
XT2005 vdd well_2005 ntap1 A=4e-12 P=8e-6
XM4_215 net31 net1 vdd well_2005 sg13_lv_pmos w=1u l=1u m=1
XT2006 vdd well_2006 ntap1 A=4e-12 P=8e-6
XM4_216 net31 net1 vdd well_2006 sg13_lv_pmos w=1u l=1u m=1
XT2007 vdd well_2007 ntap1 A=4e-12 P=8e-6
XM4_217 net31 net1 vdd well_2007 sg13_lv_pmos w=1u l=1u m=1
XT2008 vdd well_2008 ntap1 A=4e-12 P=8e-6
XM4_218 net31 net1 vdd well_2008 sg13_lv_pmos w=1u l=1u m=1
XT2009 vdd well_2009 ntap1 A=4e-12 P=8e-6
XM4_219 net31 net1 vdd well_2009 sg13_lv_pmos w=1u l=1u m=1
XT2010 vdd well_2010 ntap1 A=4e-12 P=8e-6
XM4_220 net31 net1 vdd well_2010 sg13_lv_pmos w=1u l=1u m=1
XT2011 vdd well_2011 ntap1 A=4e-12 P=8e-6
XM4_221 net31 net1 vdd well_2011 sg13_lv_pmos w=1u l=1u m=1
XT2012 vdd well_2012 ntap1 A=4e-12 P=8e-6
XM4_222 net31 net1 vdd well_2012 sg13_lv_pmos w=1u l=1u m=1
XT2013 vdd well_2013 ntap1 A=4e-12 P=8e-6
XM4_223 net31 net1 vdd well_2013 sg13_lv_pmos w=1u l=1u m=1
XT2014 vdd well_2014 ntap1 A=4e-12 P=8e-6
XM4_224 net31 net1 vdd well_2014 sg13_lv_pmos w=1u l=1u m=1
XT2015 vdd well_2015 ntap1 A=4e-12 P=8e-6
XM4_225 net31 net1 vdd well_2015 sg13_lv_pmos w=1u l=1u m=1
XT2016 vdd well_2016 ntap1 A=4e-12 P=8e-6
XM4_226 net31 net1 vdd well_2016 sg13_lv_pmos w=1u l=1u m=1
XT2017 vdd well_2017 ntap1 A=4e-12 P=8e-6
XM4_227 net31 net1 vdd well_2017 sg13_lv_pmos w=1u l=1u m=1
XT2018 vdd well_2018 ntap1 A=4e-12 P=8e-6
XM4_228 net31 net1 vdd well_2018 sg13_lv_pmos w=1u l=1u m=1
XT2019 vdd well_2019 ntap1 A=4e-12 P=8e-6
XM4_229 net31 net1 vdd well_2019 sg13_lv_pmos w=1u l=1u m=1
XT2020 vdd well_2020 ntap1 A=4e-12 P=8e-6
XM4_230 net31 net1 vdd well_2020 sg13_lv_pmos w=1u l=1u m=1
XT2021 vdd well_2021 ntap1 A=4e-12 P=8e-6
XM4_231 net31 net1 vdd well_2021 sg13_lv_pmos w=1u l=1u m=1
XT2022 vdd well_2022 ntap1 A=4e-12 P=8e-6
XM4_232 net31 net1 vdd well_2022 sg13_lv_pmos w=1u l=1u m=1
XT2023 vdd well_2023 ntap1 A=4e-12 P=8e-6
XM4_233 net31 net1 vdd well_2023 sg13_lv_pmos w=1u l=1u m=1
XT2024 vdd well_2024 ntap1 A=4e-12 P=8e-6
XM4_234 net31 net1 vdd well_2024 sg13_lv_pmos w=1u l=1u m=1
XT2025 vdd well_2025 ntap1 A=4e-12 P=8e-6
XM4_235 net31 net1 vdd well_2025 sg13_lv_pmos w=1u l=1u m=1
XT2026 vdd well_2026 ntap1 A=4e-12 P=8e-6
XM4_236 net31 net1 vdd well_2026 sg13_lv_pmos w=1u l=1u m=1
XT2027 vdd well_2027 ntap1 A=4e-12 P=8e-6
XM4_237 net31 net1 vdd well_2027 sg13_lv_pmos w=1u l=1u m=1
XT2028 vdd well_2028 ntap1 A=4e-12 P=8e-6
XM4_238 net31 net1 vdd well_2028 sg13_lv_pmos w=1u l=1u m=1
XT2029 vdd well_2029 ntap1 A=4e-12 P=8e-6
XM4_239 net31 net1 vdd well_2029 sg13_lv_pmos w=1u l=1u m=1
XT2030 vdd well_2030 ntap1 A=4e-12 P=8e-6
XM4_240 net31 net1 vdd well_2030 sg13_lv_pmos w=1u l=1u m=1
XT2031 vdd well_2031 ntap1 A=4e-12 P=8e-6
XM4_241 net31 net1 vdd well_2031 sg13_lv_pmos w=1u l=1u m=1
XT2032 vdd well_2032 ntap1 A=4e-12 P=8e-6
XM4_242 net31 net1 vdd well_2032 sg13_lv_pmos w=1u l=1u m=1
XT2033 vdd well_2033 ntap1 A=4e-12 P=8e-6
XM4_243 net31 net1 vdd well_2033 sg13_lv_pmos w=1u l=1u m=1
XT2034 vdd well_2034 ntap1 A=4e-12 P=8e-6
XM4_244 net31 net1 vdd well_2034 sg13_lv_pmos w=1u l=1u m=1
XT2035 vdd well_2035 ntap1 A=4e-12 P=8e-6
XM4_245 net31 net1 vdd well_2035 sg13_lv_pmos w=1u l=1u m=1
XT2036 vdd well_2036 ntap1 A=4e-12 P=8e-6
XM4_246 net31 net1 vdd well_2036 sg13_lv_pmos w=1u l=1u m=1
XT2037 vdd well_2037 ntap1 A=4e-12 P=8e-6
XM4_247 net31 net1 vdd well_2037 sg13_lv_pmos w=1u l=1u m=1
XT2038 vdd well_2038 ntap1 A=4e-12 P=8e-6
XM4_248 net31 net1 vdd well_2038 sg13_lv_pmos w=1u l=1u m=1
XT2039 vdd well_2039 ntap1 A=4e-12 P=8e-6
XM4_249 net31 net1 vdd well_2039 sg13_lv_pmos w=1u l=1u m=1
XT2040 vdd well_2040 ntap1 A=4e-12 P=8e-6
XM4_250 net31 net1 vdd well_2040 sg13_lv_pmos w=1u l=1u m=1
XT2041 vdd well_2041 ntap1 A=4e-12 P=8e-6
XM4_251 net31 net1 vdd well_2041 sg13_lv_pmos w=1u l=1u m=1
XT2042 vdd well_2042 ntap1 A=4e-12 P=8e-6
XM4_252 net31 net1 vdd well_2042 sg13_lv_pmos w=1u l=1u m=1
XT2043 vdd well_2043 ntap1 A=4e-12 P=8e-6
XM4_253 net31 net1 vdd well_2043 sg13_lv_pmos w=1u l=1u m=1
XT2044 vdd well_2044 ntap1 A=4e-12 P=8e-6
XM4_254 net31 net1 vdd well_2044 sg13_lv_pmos w=1u l=1u m=1
XT2045 vdd well_2045 ntap1 A=4e-12 P=8e-6
XM4_255 net31 net1 vdd well_2045 sg13_lv_pmos w=1u l=1u m=1
XT2046 vdd well_2046 ntap1 A=4e-12 P=8e-6
XM4_256 net31 net1 vdd well_2046 sg13_lv_pmos w=1u l=1u m=1
XT2047 vdd well_2047 ntap1 A=4e-12 P=8e-6
XM4_257 net31 net1 vdd well_2047 sg13_lv_pmos w=1u l=1u m=1
XT2048 vdd well_2048 ntap1 A=4e-12 P=8e-6
XM4_258 net31 net1 vdd well_2048 sg13_lv_pmos w=1u l=1u m=1
XT2049 vdd well_2049 ntap1 A=4e-12 P=8e-6
XM4_259 net31 net1 vdd well_2049 sg13_lv_pmos w=1u l=1u m=1
XT2050 vdd well_2050 ntap1 A=4e-12 P=8e-6
XM4_260 net31 net1 vdd well_2050 sg13_lv_pmos w=1u l=1u m=1
XT2051 vdd well_2051 ntap1 A=4e-12 P=8e-6
XM4_261 net31 net1 vdd well_2051 sg13_lv_pmos w=1u l=1u m=1
XT2052 vdd well_2052 ntap1 A=4e-12 P=8e-6
XM4_262 net31 net1 vdd well_2052 sg13_lv_pmos w=1u l=1u m=1
XT2053 vdd well_2053 ntap1 A=4e-12 P=8e-6
XM4_263 net31 net1 vdd well_2053 sg13_lv_pmos w=1u l=1u m=1
XT2054 vdd well_2054 ntap1 A=4e-12 P=8e-6
XM4_264 net31 net1 vdd well_2054 sg13_lv_pmos w=1u l=1u m=1
XT2055 vdd well_2055 ntap1 A=4e-12 P=8e-6
XM4_265 net31 net1 vdd well_2055 sg13_lv_pmos w=1u l=1u m=1
XT2056 vdd well_2056 ntap1 A=4e-12 P=8e-6
XM4_266 net31 net1 vdd well_2056 sg13_lv_pmos w=1u l=1u m=1
XT2057 vdd well_2057 ntap1 A=4e-12 P=8e-6
XM4_267 net31 net1 vdd well_2057 sg13_lv_pmos w=1u l=1u m=1
XT2058 vdd well_2058 ntap1 A=4e-12 P=8e-6
XM4_268 net31 net1 vdd well_2058 sg13_lv_pmos w=1u l=1u m=1
XT2059 vdd well_2059 ntap1 A=4e-12 P=8e-6
XM4_269 net31 net1 vdd well_2059 sg13_lv_pmos w=1u l=1u m=1
XT2060 vdd well_2060 ntap1 A=4e-12 P=8e-6
XM4_270 net31 net1 vdd well_2060 sg13_lv_pmos w=1u l=1u m=1
XT2061 vdd well_2061 ntap1 A=4e-12 P=8e-6
XM4_271 net31 net1 vdd well_2061 sg13_lv_pmos w=1u l=1u m=1
XT2062 vdd well_2062 ntap1 A=4e-12 P=8e-6
XM4_272 net31 net1 vdd well_2062 sg13_lv_pmos w=1u l=1u m=1
XT2063 vdd well_2063 ntap1 A=4e-12 P=8e-6
XM4_273 net31 net1 vdd well_2063 sg13_lv_pmos w=1u l=1u m=1
XT2064 vdd well_2064 ntap1 A=4e-12 P=8e-6
XM4_274 net31 net1 vdd well_2064 sg13_lv_pmos w=1u l=1u m=1
XT2065 vdd well_2065 ntap1 A=4e-12 P=8e-6
XM4_275 net31 net1 vdd well_2065 sg13_lv_pmos w=1u l=1u m=1
XT2066 vdd well_2066 ntap1 A=4e-12 P=8e-6
XM4_276 net31 net1 vdd well_2066 sg13_lv_pmos w=1u l=1u m=1
XT2067 vdd well_2067 ntap1 A=4e-12 P=8e-6
XM4_277 net31 net1 vdd well_2067 sg13_lv_pmos w=1u l=1u m=1
XT2068 vdd well_2068 ntap1 A=4e-12 P=8e-6
XM4_278 net31 net1 vdd well_2068 sg13_lv_pmos w=1u l=1u m=1
XT2069 vdd well_2069 ntap1 A=4e-12 P=8e-6
XM4_279 net31 net1 vdd well_2069 sg13_lv_pmos w=1u l=1u m=1
XT2070 vdd well_2070 ntap1 A=4e-12 P=8e-6
XM4_280 net31 net1 vdd well_2070 sg13_lv_pmos w=1u l=1u m=1
XT2071 vdd well_2071 ntap1 A=4e-12 P=8e-6
XM4_281 net31 net1 vdd well_2071 sg13_lv_pmos w=1u l=1u m=1
XT2072 vdd well_2072 ntap1 A=4e-12 P=8e-6
XM4_282 net31 net1 vdd well_2072 sg13_lv_pmos w=1u l=1u m=1
XT2073 vdd well_2073 ntap1 A=4e-12 P=8e-6
XM4_283 net31 net1 vdd well_2073 sg13_lv_pmos w=1u l=1u m=1
XT2074 vdd well_2074 ntap1 A=4e-12 P=8e-6
XM5_0 voutn voutn vdd well_2074 sg13_lv_pmos w=1u l=1u m=1
XT2075 vdd well_2075 ntap1 A=4e-12 P=8e-6
XM5_1 voutn voutn vdd well_2075 sg13_lv_pmos w=1u l=1u m=1
XT2076 vdd well_2076 ntap1 A=4e-12 P=8e-6
XM5_2 voutn voutn vdd well_2076 sg13_lv_pmos w=1u l=1u m=1
XT2077 vdd well_2077 ntap1 A=4e-12 P=8e-6
XM5_3 voutn voutn vdd well_2077 sg13_lv_pmos w=1u l=1u m=1
XT2078 vdd well_2078 ntap1 A=4e-12 P=8e-6
XM5_4 voutn voutn vdd well_2078 sg13_lv_pmos w=1u l=1u m=1
XT2079 vdd well_2079 ntap1 A=4e-12 P=8e-6
XM5_5 voutn voutn vdd well_2079 sg13_lv_pmos w=1u l=1u m=1
XT2080 vdd well_2080 ntap1 A=4e-12 P=8e-6
XM5_6 voutn voutn vdd well_2080 sg13_lv_pmos w=1u l=1u m=1
XT2081 vdd well_2081 ntap1 A=4e-12 P=8e-6
XM5_7 voutn voutn vdd well_2081 sg13_lv_pmos w=1u l=1u m=1
XT2082 vdd well_2082 ntap1 A=4e-12 P=8e-6
XM5_8 voutn voutn vdd well_2082 sg13_lv_pmos w=1u l=1u m=1
XT2083 vdd well_2083 ntap1 A=4e-12 P=8e-6
XM5_9 voutn voutn vdd well_2083 sg13_lv_pmos w=1u l=1u m=1
XT2084 vdd well_2084 ntap1 A=4e-12 P=8e-6
XM5_10 voutn voutn vdd well_2084 sg13_lv_pmos w=1u l=1u m=1
XT2085 vdd well_2085 ntap1 A=4e-12 P=8e-6
XM5_11 voutn voutn vdd well_2085 sg13_lv_pmos w=1u l=1u m=1
XT2086 vdd well_2086 ntap1 A=4e-12 P=8e-6
XM5_12 voutn voutn vdd well_2086 sg13_lv_pmos w=1u l=1u m=1
XT2087 vdd well_2087 ntap1 A=4e-12 P=8e-6
XM5_13 voutn voutn vdd well_2087 sg13_lv_pmos w=1u l=1u m=1
XT2088 vdd well_2088 ntap1 A=4e-12 P=8e-6
XM5_14 voutn voutn vdd well_2088 sg13_lv_pmos w=1u l=1u m=1
XT2089 vdd well_2089 ntap1 A=4e-12 P=8e-6
XM5_15 voutn voutn vdd well_2089 sg13_lv_pmos w=1u l=1u m=1
XT2090 vdd well_2090 ntap1 A=4e-12 P=8e-6
XM5_16 voutn voutn vdd well_2090 sg13_lv_pmos w=1u l=1u m=1
XT2091 vdd well_2091 ntap1 A=4e-12 P=8e-6
XM5_17 voutn voutn vdd well_2091 sg13_lv_pmos w=1u l=1u m=1
XT2092 vdd well_2092 ntap1 A=4e-12 P=8e-6
XM5_18 voutn voutn vdd well_2092 sg13_lv_pmos w=1u l=1u m=1
XT2093 vdd well_2093 ntap1 A=4e-12 P=8e-6
XM5_19 voutn voutn vdd well_2093 sg13_lv_pmos w=1u l=1u m=1
XT2094 vdd well_2094 ntap1 A=4e-12 P=8e-6
XM5_20 voutn voutn vdd well_2094 sg13_lv_pmos w=1u l=1u m=1
XT2095 vdd well_2095 ntap1 A=4e-12 P=8e-6
XM5_21 voutn voutn vdd well_2095 sg13_lv_pmos w=1u l=1u m=1
XT2096 vdd well_2096 ntap1 A=4e-12 P=8e-6
XM5_22 voutn voutn vdd well_2096 sg13_lv_pmos w=1u l=1u m=1
XT2097 vdd well_2097 ntap1 A=4e-12 P=8e-6
XM5_23 voutn voutn vdd well_2097 sg13_lv_pmos w=1u l=1u m=1
XT2098 vdd well_2098 ntap1 A=4e-12 P=8e-6
XM5_24 voutn voutn vdd well_2098 sg13_lv_pmos w=1u l=1u m=1
XT2099 vdd well_2099 ntap1 A=4e-12 P=8e-6
XM5_25 voutn voutn vdd well_2099 sg13_lv_pmos w=1u l=1u m=1
XT2100 vdd well_2100 ntap1 A=4e-12 P=8e-6
XM5_26 voutn voutn vdd well_2100 sg13_lv_pmos w=1u l=1u m=1
XT2101 vdd well_2101 ntap1 A=4e-12 P=8e-6
XM5_27 voutn voutn vdd well_2101 sg13_lv_pmos w=1u l=1u m=1
XT2102 vdd well_2102 ntap1 A=4e-12 P=8e-6
XM5_28 voutn voutn vdd well_2102 sg13_lv_pmos w=1u l=1u m=1
XT2103 vdd well_2103 ntap1 A=4e-12 P=8e-6
XM5_29 voutn voutn vdd well_2103 sg13_lv_pmos w=1u l=1u m=1
XT2104 vdd well_2104 ntap1 A=4e-12 P=8e-6
XM5_30 voutn voutn vdd well_2104 sg13_lv_pmos w=1u l=1u m=1
XT2105 vdd well_2105 ntap1 A=4e-12 P=8e-6
XM5_31 voutn voutn vdd well_2105 sg13_lv_pmos w=1u l=1u m=1
XT2106 vdd well_2106 ntap1 A=4e-12 P=8e-6
XM5_32 voutn voutn vdd well_2106 sg13_lv_pmos w=1u l=1u m=1
XT2107 vdd well_2107 ntap1 A=4e-12 P=8e-6
XM5_33 voutn voutn vdd well_2107 sg13_lv_pmos w=1u l=1u m=1
XT2108 vdd well_2108 ntap1 A=4e-12 P=8e-6
XM5_34 voutn voutn vdd well_2108 sg13_lv_pmos w=1u l=1u m=1
XT2109 vdd well_2109 ntap1 A=4e-12 P=8e-6
XM5_35 voutn voutn vdd well_2109 sg13_lv_pmos w=1u l=1u m=1
XT2110 vdd well_2110 ntap1 A=4e-12 P=8e-6
XM5_36 voutn voutn vdd well_2110 sg13_lv_pmos w=1u l=1u m=1
XT2111 vdd well_2111 ntap1 A=4e-12 P=8e-6
XM5_37 voutn voutn vdd well_2111 sg13_lv_pmos w=1u l=1u m=1
XT2112 vdd well_2112 ntap1 A=4e-12 P=8e-6
XM5_38 voutn voutn vdd well_2112 sg13_lv_pmos w=1u l=1u m=1
XT2113 vdd well_2113 ntap1 A=4e-12 P=8e-6
XM5_39 voutn voutn vdd well_2113 sg13_lv_pmos w=1u l=1u m=1
XT2114 vdd well_2114 ntap1 A=4e-12 P=8e-6
XM5_40 voutn voutn vdd well_2114 sg13_lv_pmos w=1u l=1u m=1
XT2115 vdd well_2115 ntap1 A=4e-12 P=8e-6
XM5_41 voutn voutn vdd well_2115 sg13_lv_pmos w=1u l=1u m=1
XT2116 vdd well_2116 ntap1 A=4e-12 P=8e-6
XM5_42 voutn voutn vdd well_2116 sg13_lv_pmos w=1u l=1u m=1
XT2117 vdd well_2117 ntap1 A=4e-12 P=8e-6
XM5_43 voutn voutn vdd well_2117 sg13_lv_pmos w=1u l=1u m=1
XT2118 vdd well_2118 ntap1 A=4e-12 P=8e-6
XM5_44 voutn voutn vdd well_2118 sg13_lv_pmos w=1u l=1u m=1
XT2119 vdd well_2119 ntap1 A=4e-12 P=8e-6
XM5_45 voutn voutn vdd well_2119 sg13_lv_pmos w=1u l=1u m=1
XT2120 vdd well_2120 ntap1 A=4e-12 P=8e-6
XM5_46 voutn voutn vdd well_2120 sg13_lv_pmos w=1u l=1u m=1
XT2121 vdd well_2121 ntap1 A=4e-12 P=8e-6
XM5_47 voutn voutn vdd well_2121 sg13_lv_pmos w=1u l=1u m=1
XT2122 vdd well_2122 ntap1 A=4e-12 P=8e-6
XM5_48 voutn voutn vdd well_2122 sg13_lv_pmos w=1u l=1u m=1
XT2123 vdd well_2123 ntap1 A=4e-12 P=8e-6
XM5_49 voutn voutn vdd well_2123 sg13_lv_pmos w=1u l=1u m=1
XT2124 vdd well_2124 ntap1 A=4e-12 P=8e-6
XM5_50 voutn voutn vdd well_2124 sg13_lv_pmos w=1u l=1u m=1
XT2125 vdd well_2125 ntap1 A=4e-12 P=8e-6
XM5_51 voutn voutn vdd well_2125 sg13_lv_pmos w=1u l=1u m=1
XT2126 vdd well_2126 ntap1 A=4e-12 P=8e-6
XM5_52 voutn voutn vdd well_2126 sg13_lv_pmos w=1u l=1u m=1
XT2127 vdd well_2127 ntap1 A=4e-12 P=8e-6
XM5_53 voutn voutn vdd well_2127 sg13_lv_pmos w=1u l=1u m=1
XT2128 vdd well_2128 ntap1 A=4e-12 P=8e-6
XM5_54 voutn voutn vdd well_2128 sg13_lv_pmos w=1u l=1u m=1
XT2129 vdd well_2129 ntap1 A=4e-12 P=8e-6
XM5_55 voutn voutn vdd well_2129 sg13_lv_pmos w=1u l=1u m=1
XT2130 vdd well_2130 ntap1 A=4e-12 P=8e-6
XM5_56 voutn voutn vdd well_2130 sg13_lv_pmos w=1u l=1u m=1
XT2131 vdd well_2131 ntap1 A=4e-12 P=8e-6
XM5_57 voutn voutn vdd well_2131 sg13_lv_pmos w=1u l=1u m=1
XT2132 vdd well_2132 ntap1 A=4e-12 P=8e-6
XM5_58 voutn voutn vdd well_2132 sg13_lv_pmos w=1u l=1u m=1
XT2133 vdd well_2133 ntap1 A=4e-12 P=8e-6
XM5_59 voutn voutn vdd well_2133 sg13_lv_pmos w=1u l=1u m=1
XT2134 vdd well_2134 ntap1 A=4e-12 P=8e-6
XM5_60 voutn voutn vdd well_2134 sg13_lv_pmos w=1u l=1u m=1
XT2135 vdd well_2135 ntap1 A=4e-12 P=8e-6
XM5_61 voutn voutn vdd well_2135 sg13_lv_pmos w=1u l=1u m=1
XT2136 vdd well_2136 ntap1 A=4e-12 P=8e-6
XM5_62 voutn voutn vdd well_2136 sg13_lv_pmos w=1u l=1u m=1
XT2137 vdd well_2137 ntap1 A=4e-12 P=8e-6
XM5_63 voutn voutn vdd well_2137 sg13_lv_pmos w=1u l=1u m=1
XT2138 vdd well_2138 ntap1 A=4e-12 P=8e-6
XM5_64 voutn voutn vdd well_2138 sg13_lv_pmos w=1u l=1u m=1
XT2139 vdd well_2139 ntap1 A=4e-12 P=8e-6
XM5_65 voutn voutn vdd well_2139 sg13_lv_pmos w=1u l=1u m=1
XT2140 vdd well_2140 ntap1 A=4e-12 P=8e-6
XM5_66 voutn voutn vdd well_2140 sg13_lv_pmos w=1u l=1u m=1
XT2141 vdd well_2141 ntap1 A=4e-12 P=8e-6
XM5_67 voutn voutn vdd well_2141 sg13_lv_pmos w=1u l=1u m=1
XT2142 vdd well_2142 ntap1 A=4e-12 P=8e-6
XM5_68 voutn voutn vdd well_2142 sg13_lv_pmos w=1u l=1u m=1
XT2143 vdd well_2143 ntap1 A=4e-12 P=8e-6
XM5_69 voutn voutn vdd well_2143 sg13_lv_pmos w=1u l=1u m=1
XT2144 vdd well_2144 ntap1 A=4e-12 P=8e-6
XM5_70 voutn voutn vdd well_2144 sg13_lv_pmos w=1u l=1u m=1
XT2145 vdd well_2145 ntap1 A=4e-12 P=8e-6
XM6_0 net050 voutn vdd well_2145 sg13_lv_pmos w=1u l=1u m=1
XT2146 vdd well_2146 ntap1 A=4e-12 P=8e-6
XM6_1 net050 voutn vdd well_2146 sg13_lv_pmos w=1u l=1u m=1
XT2147 vdd well_2147 ntap1 A=4e-12 P=8e-6
XM6_2 net050 voutn vdd well_2147 sg13_lv_pmos w=1u l=1u m=1
XT2148 vdd well_2148 ntap1 A=4e-12 P=8e-6
XM6_3 net050 voutn vdd well_2148 sg13_lv_pmos w=1u l=1u m=1
XT2149 vdd well_2149 ntap1 A=4e-12 P=8e-6
XM6_4 net050 voutn vdd well_2149 sg13_lv_pmos w=1u l=1u m=1
XT2150 vdd well_2150 ntap1 A=4e-12 P=8e-6
XM6_5 net050 voutn vdd well_2150 sg13_lv_pmos w=1u l=1u m=1
XT2151 vdd well_2151 ntap1 A=4e-12 P=8e-6
XM6_6 net050 voutn vdd well_2151 sg13_lv_pmos w=1u l=1u m=1
XT2152 vdd well_2152 ntap1 A=4e-12 P=8e-6
XM6_7 net050 voutn vdd well_2152 sg13_lv_pmos w=1u l=1u m=1
XT2153 vdd well_2153 ntap1 A=4e-12 P=8e-6
XM6_8 net050 voutn vdd well_2153 sg13_lv_pmos w=1u l=1u m=1
XT2154 vdd well_2154 ntap1 A=4e-12 P=8e-6
XM6_9 net050 voutn vdd well_2154 sg13_lv_pmos w=1u l=1u m=1
XT2155 vdd well_2155 ntap1 A=4e-12 P=8e-6
XM6_10 net050 voutn vdd well_2155 sg13_lv_pmos w=1u l=1u m=1
XT2156 vdd well_2156 ntap1 A=4e-12 P=8e-6
XM6_11 net050 voutn vdd well_2156 sg13_lv_pmos w=1u l=1u m=1
XT2157 vdd well_2157 ntap1 A=4e-12 P=8e-6
XM6_12 net050 voutn vdd well_2157 sg13_lv_pmos w=1u l=1u m=1
XT2158 vdd well_2158 ntap1 A=4e-12 P=8e-6
XM6_13 net050 voutn vdd well_2158 sg13_lv_pmos w=1u l=1u m=1
XT2159 vdd well_2159 ntap1 A=4e-12 P=8e-6
XM6_14 net050 voutn vdd well_2159 sg13_lv_pmos w=1u l=1u m=1
XT2160 vdd well_2160 ntap1 A=4e-12 P=8e-6
XM6_15 net050 voutn vdd well_2160 sg13_lv_pmos w=1u l=1u m=1
XT2161 vdd well_2161 ntap1 A=4e-12 P=8e-6
XM6_16 net050 voutn vdd well_2161 sg13_lv_pmos w=1u l=1u m=1
XT2162 vdd well_2162 ntap1 A=4e-12 P=8e-6
XM6_17 net050 voutn vdd well_2162 sg13_lv_pmos w=1u l=1u m=1
XT2163 vdd well_2163 ntap1 A=4e-12 P=8e-6
XM6_18 net050 voutn vdd well_2163 sg13_lv_pmos w=1u l=1u m=1
XT2164 vdd well_2164 ntap1 A=4e-12 P=8e-6
XM6_19 net050 voutn vdd well_2164 sg13_lv_pmos w=1u l=1u m=1
XT2165 vdd well_2165 ntap1 A=4e-12 P=8e-6
XM6_20 net050 voutn vdd well_2165 sg13_lv_pmos w=1u l=1u m=1
XT2166 vdd well_2166 ntap1 A=4e-12 P=8e-6
XM6_21 net050 voutn vdd well_2166 sg13_lv_pmos w=1u l=1u m=1
XT2167 vdd well_2167 ntap1 A=4e-12 P=8e-6
XM6_22 net050 voutn vdd well_2167 sg13_lv_pmos w=1u l=1u m=1
XT2168 vdd well_2168 ntap1 A=4e-12 P=8e-6
XM6_23 net050 voutn vdd well_2168 sg13_lv_pmos w=1u l=1u m=1
XT2169 vdd well_2169 ntap1 A=4e-12 P=8e-6
XM6_24 net050 voutn vdd well_2169 sg13_lv_pmos w=1u l=1u m=1
XT2170 vdd well_2170 ntap1 A=4e-12 P=8e-6
XM6_25 net050 voutn vdd well_2170 sg13_lv_pmos w=1u l=1u m=1
XT2171 vdd well_2171 ntap1 A=4e-12 P=8e-6
XM6_26 net050 voutn vdd well_2171 sg13_lv_pmos w=1u l=1u m=1
XT2172 vdd well_2172 ntap1 A=4e-12 P=8e-6
XM6_27 net050 voutn vdd well_2172 sg13_lv_pmos w=1u l=1u m=1
XT2173 vdd well_2173 ntap1 A=4e-12 P=8e-6
XM6_28 net050 voutn vdd well_2173 sg13_lv_pmos w=1u l=1u m=1
XT2174 vdd well_2174 ntap1 A=4e-12 P=8e-6
XM6_29 net050 voutn vdd well_2174 sg13_lv_pmos w=1u l=1u m=1
XT2175 vdd well_2175 ntap1 A=4e-12 P=8e-6
XM6_30 net050 voutn vdd well_2175 sg13_lv_pmos w=1u l=1u m=1
XT2176 vdd well_2176 ntap1 A=4e-12 P=8e-6
XM6_31 net050 voutn vdd well_2176 sg13_lv_pmos w=1u l=1u m=1
XT2177 vdd well_2177 ntap1 A=4e-12 P=8e-6
XM6_32 net050 voutn vdd well_2177 sg13_lv_pmos w=1u l=1u m=1
XT2178 vdd well_2178 ntap1 A=4e-12 P=8e-6
XM6_33 net050 voutn vdd well_2178 sg13_lv_pmos w=1u l=1u m=1
XT2179 vdd well_2179 ntap1 A=4e-12 P=8e-6
XM6_34 net050 voutn vdd well_2179 sg13_lv_pmos w=1u l=1u m=1
XT2180 vdd well_2180 ntap1 A=4e-12 P=8e-6
XM6_35 net050 voutn vdd well_2180 sg13_lv_pmos w=1u l=1u m=1
XT2181 vdd well_2181 ntap1 A=4e-12 P=8e-6
XM6_36 net050 voutn vdd well_2181 sg13_lv_pmos w=1u l=1u m=1
XT2182 vdd well_2182 ntap1 A=4e-12 P=8e-6
XM6_37 net050 voutn vdd well_2182 sg13_lv_pmos w=1u l=1u m=1
XT2183 vdd well_2183 ntap1 A=4e-12 P=8e-6
XM6_38 net050 voutn vdd well_2183 sg13_lv_pmos w=1u l=1u m=1
XT2184 vdd well_2184 ntap1 A=4e-12 P=8e-6
XM6_39 net050 voutn vdd well_2184 sg13_lv_pmos w=1u l=1u m=1
XT2185 vdd well_2185 ntap1 A=4e-12 P=8e-6
XM6_40 net050 voutn vdd well_2185 sg13_lv_pmos w=1u l=1u m=1
XT2186 vdd well_2186 ntap1 A=4e-12 P=8e-6
XM6_41 net050 voutn vdd well_2186 sg13_lv_pmos w=1u l=1u m=1
XT2187 vdd well_2187 ntap1 A=4e-12 P=8e-6
XM6_42 net050 voutn vdd well_2187 sg13_lv_pmos w=1u l=1u m=1
XT2188 vdd well_2188 ntap1 A=4e-12 P=8e-6
XM6_43 net050 voutn vdd well_2188 sg13_lv_pmos w=1u l=1u m=1
XT2189 vdd well_2189 ntap1 A=4e-12 P=8e-6
XM6_44 net050 voutn vdd well_2189 sg13_lv_pmos w=1u l=1u m=1
XT2190 vdd well_2190 ntap1 A=4e-12 P=8e-6
XM6_45 net050 voutn vdd well_2190 sg13_lv_pmos w=1u l=1u m=1
XT2191 vdd well_2191 ntap1 A=4e-12 P=8e-6
XM6_46 net050 voutn vdd well_2191 sg13_lv_pmos w=1u l=1u m=1
XT2192 vdd well_2192 ntap1 A=4e-12 P=8e-6
XM6_47 net050 voutn vdd well_2192 sg13_lv_pmos w=1u l=1u m=1
XT2193 vdd well_2193 ntap1 A=4e-12 P=8e-6
XM6_48 net050 voutn vdd well_2193 sg13_lv_pmos w=1u l=1u m=1
XT2194 vdd well_2194 ntap1 A=4e-12 P=8e-6
XM6_49 net050 voutn vdd well_2194 sg13_lv_pmos w=1u l=1u m=1
XT2195 vdd well_2195 ntap1 A=4e-12 P=8e-6
XM6_50 net050 voutn vdd well_2195 sg13_lv_pmos w=1u l=1u m=1
XT2196 vdd well_2196 ntap1 A=4e-12 P=8e-6
XM6_51 net050 voutn vdd well_2196 sg13_lv_pmos w=1u l=1u m=1
XT2197 vdd well_2197 ntap1 A=4e-12 P=8e-6
XM6_52 net050 voutn vdd well_2197 sg13_lv_pmos w=1u l=1u m=1
XT2198 vdd well_2198 ntap1 A=4e-12 P=8e-6
XM6_53 net050 voutn vdd well_2198 sg13_lv_pmos w=1u l=1u m=1
XT2199 vdd well_2199 ntap1 A=4e-12 P=8e-6
XM6_54 net050 voutn vdd well_2199 sg13_lv_pmos w=1u l=1u m=1
XT2200 vdd well_2200 ntap1 A=4e-12 P=8e-6
XM6_55 net050 voutn vdd well_2200 sg13_lv_pmos w=1u l=1u m=1
XT2201 vdd well_2201 ntap1 A=4e-12 P=8e-6
XM6_56 net050 voutn vdd well_2201 sg13_lv_pmos w=1u l=1u m=1
XT2202 vdd well_2202 ntap1 A=4e-12 P=8e-6
XM6_57 net050 voutn vdd well_2202 sg13_lv_pmos w=1u l=1u m=1
XT2203 vdd well_2203 ntap1 A=4e-12 P=8e-6
XM6_58 net050 voutn vdd well_2203 sg13_lv_pmos w=1u l=1u m=1
XT2204 vdd well_2204 ntap1 A=4e-12 P=8e-6
XM6_59 net050 voutn vdd well_2204 sg13_lv_pmos w=1u l=1u m=1
XT2205 vdd well_2205 ntap1 A=4e-12 P=8e-6
XM6_60 net050 voutn vdd well_2205 sg13_lv_pmos w=1u l=1u m=1
XT2206 vdd well_2206 ntap1 A=4e-12 P=8e-6
XM6_61 net050 voutn vdd well_2206 sg13_lv_pmos w=1u l=1u m=1
XT2207 vdd well_2207 ntap1 A=4e-12 P=8e-6
XM6_62 net050 voutn vdd well_2207 sg13_lv_pmos w=1u l=1u m=1
XT2208 vdd well_2208 ntap1 A=4e-12 P=8e-6
XM6_63 net050 voutn vdd well_2208 sg13_lv_pmos w=1u l=1u m=1
XT2209 vdd well_2209 ntap1 A=4e-12 P=8e-6
XM6_64 net050 voutn vdd well_2209 sg13_lv_pmos w=1u l=1u m=1
XT2210 vdd well_2210 ntap1 A=4e-12 P=8e-6
XM6_65 net050 voutn vdd well_2210 sg13_lv_pmos w=1u l=1u m=1
XT2211 vdd well_2211 ntap1 A=4e-12 P=8e-6
XM6_66 net050 voutn vdd well_2211 sg13_lv_pmos w=1u l=1u m=1
XT2212 vdd well_2212 ntap1 A=4e-12 P=8e-6
XM6_67 net050 voutn vdd well_2212 sg13_lv_pmos w=1u l=1u m=1
XT2213 vdd well_2213 ntap1 A=4e-12 P=8e-6
XM6_68 net050 voutn vdd well_2213 sg13_lv_pmos w=1u l=1u m=1
XT2214 vdd well_2214 ntap1 A=4e-12 P=8e-6
XM6_69 net050 voutn vdd well_2214 sg13_lv_pmos w=1u l=1u m=1
XT2215 vdd well_2215 ntap1 A=4e-12 P=8e-6
XM6_70 net050 voutn vdd well_2215 sg13_lv_pmos w=1u l=1u m=1
XT2216 vdd well_2216 ntap1 A=4e-12 P=8e-6
XM7_0 net049 net1 vdd well_2216 sg13_lv_pmos w=1u l=1u m=1
XT2217 vdd well_2217 ntap1 A=4e-12 P=8e-6
XM7_1 net049 net1 vdd well_2217 sg13_lv_pmos w=1u l=1u m=1
XT2218 vdd well_2218 ntap1 A=4e-12 P=8e-6
XM7_2 net049 net1 vdd well_2218 sg13_lv_pmos w=1u l=1u m=1
XT2219 vdd well_2219 ntap1 A=4e-12 P=8e-6
XM7_3 net049 net1 vdd well_2219 sg13_lv_pmos w=1u l=1u m=1
XT2220 vdd well_2220 ntap1 A=4e-12 P=8e-6
XM7_4 net049 net1 vdd well_2220 sg13_lv_pmos w=1u l=1u m=1
XT2221 vdd well_2221 ntap1 A=4e-12 P=8e-6
XM7_5 net049 net1 vdd well_2221 sg13_lv_pmos w=1u l=1u m=1
XT2222 vdd well_2222 ntap1 A=4e-12 P=8e-6
XM7_6 net049 net1 vdd well_2222 sg13_lv_pmos w=1u l=1u m=1
XT2223 vdd well_2223 ntap1 A=4e-12 P=8e-6
XM7_7 net049 net1 vdd well_2223 sg13_lv_pmos w=1u l=1u m=1
XT2224 vdd well_2224 ntap1 A=4e-12 P=8e-6
XM7_8 net049 net1 vdd well_2224 sg13_lv_pmos w=1u l=1u m=1
XT2225 vdd well_2225 ntap1 A=4e-12 P=8e-6
XM7_9 net049 net1 vdd well_2225 sg13_lv_pmos w=1u l=1u m=1
XT2226 vdd well_2226 ntap1 A=4e-12 P=8e-6
XM7_10 net049 net1 vdd well_2226 sg13_lv_pmos w=1u l=1u m=1
XT2227 vdd well_2227 ntap1 A=4e-12 P=8e-6
XM7_11 net049 net1 vdd well_2227 sg13_lv_pmos w=1u l=1u m=1
XT2228 vdd well_2228 ntap1 A=4e-12 P=8e-6
XM7_12 net049 net1 vdd well_2228 sg13_lv_pmos w=1u l=1u m=1
XT2229 vdd well_2229 ntap1 A=4e-12 P=8e-6
XM7_13 net049 net1 vdd well_2229 sg13_lv_pmos w=1u l=1u m=1
XT2230 vdd well_2230 ntap1 A=4e-12 P=8e-6
XM7_14 net049 net1 vdd well_2230 sg13_lv_pmos w=1u l=1u m=1
XT2231 vdd well_2231 ntap1 A=4e-12 P=8e-6
XM7_15 net049 net1 vdd well_2231 sg13_lv_pmos w=1u l=1u m=1
XT2232 vdd well_2232 ntap1 A=4e-12 P=8e-6
XM7_16 net049 net1 vdd well_2232 sg13_lv_pmos w=1u l=1u m=1
XT2233 vdd well_2233 ntap1 A=4e-12 P=8e-6
XM7_17 net049 net1 vdd well_2233 sg13_lv_pmos w=1u l=1u m=1
XT2234 vdd well_2234 ntap1 A=4e-12 P=8e-6
XM7_18 net049 net1 vdd well_2234 sg13_lv_pmos w=1u l=1u m=1
XT2235 vdd well_2235 ntap1 A=4e-12 P=8e-6
XM7_19 net049 net1 vdd well_2235 sg13_lv_pmos w=1u l=1u m=1
XT2236 vdd well_2236 ntap1 A=4e-12 P=8e-6
XM7_20 net049 net1 vdd well_2236 sg13_lv_pmos w=1u l=1u m=1
XT2237 vdd well_2237 ntap1 A=4e-12 P=8e-6
XM7_21 net049 net1 vdd well_2237 sg13_lv_pmos w=1u l=1u m=1
XT2238 vdd well_2238 ntap1 A=4e-12 P=8e-6
XM7_22 net049 net1 vdd well_2238 sg13_lv_pmos w=1u l=1u m=1
XT2239 vdd well_2239 ntap1 A=4e-12 P=8e-6
XM7_23 net049 net1 vdd well_2239 sg13_lv_pmos w=1u l=1u m=1
XT2240 vdd well_2240 ntap1 A=4e-12 P=8e-6
XM7_24 net049 net1 vdd well_2240 sg13_lv_pmos w=1u l=1u m=1
XT2241 vdd well_2241 ntap1 A=4e-12 P=8e-6
XM7_25 net049 net1 vdd well_2241 sg13_lv_pmos w=1u l=1u m=1
XT2242 vdd well_2242 ntap1 A=4e-12 P=8e-6
XM7_26 net049 net1 vdd well_2242 sg13_lv_pmos w=1u l=1u m=1
XT2243 vdd well_2243 ntap1 A=4e-12 P=8e-6
XM7_27 net049 net1 vdd well_2243 sg13_lv_pmos w=1u l=1u m=1
XT2244 vdd well_2244 ntap1 A=4e-12 P=8e-6
XM7_28 net049 net1 vdd well_2244 sg13_lv_pmos w=1u l=1u m=1
XT2245 vdd well_2245 ntap1 A=4e-12 P=8e-6
XM7_29 net049 net1 vdd well_2245 sg13_lv_pmos w=1u l=1u m=1
XT2246 vdd well_2246 ntap1 A=4e-12 P=8e-6
XM7_30 net049 net1 vdd well_2246 sg13_lv_pmos w=1u l=1u m=1
XT2247 vdd well_2247 ntap1 A=4e-12 P=8e-6
XM7_31 net049 net1 vdd well_2247 sg13_lv_pmos w=1u l=1u m=1
XT2248 vdd well_2248 ntap1 A=4e-12 P=8e-6
XM7_32 net049 net1 vdd well_2248 sg13_lv_pmos w=1u l=1u m=1
XT2249 vdd well_2249 ntap1 A=4e-12 P=8e-6
XM7_33 net049 net1 vdd well_2249 sg13_lv_pmos w=1u l=1u m=1
XT2250 vdd well_2250 ntap1 A=4e-12 P=8e-6
XM7_34 net049 net1 vdd well_2250 sg13_lv_pmos w=1u l=1u m=1
XT2251 vdd well_2251 ntap1 A=4e-12 P=8e-6
XM7_35 net049 net1 vdd well_2251 sg13_lv_pmos w=1u l=1u m=1
XT2252 vdd well_2252 ntap1 A=4e-12 P=8e-6
XM7_36 net049 net1 vdd well_2252 sg13_lv_pmos w=1u l=1u m=1
XT2253 vdd well_2253 ntap1 A=4e-12 P=8e-6
XM7_37 net049 net1 vdd well_2253 sg13_lv_pmos w=1u l=1u m=1
XT2254 vdd well_2254 ntap1 A=4e-12 P=8e-6
XM7_38 net049 net1 vdd well_2254 sg13_lv_pmos w=1u l=1u m=1
XT2255 vdd well_2255 ntap1 A=4e-12 P=8e-6
XM7_39 net049 net1 vdd well_2255 sg13_lv_pmos w=1u l=1u m=1
XT2256 vdd well_2256 ntap1 A=4e-12 P=8e-6
XM7_40 net049 net1 vdd well_2256 sg13_lv_pmos w=1u l=1u m=1
XT2257 vdd well_2257 ntap1 A=4e-12 P=8e-6
XM7_41 net049 net1 vdd well_2257 sg13_lv_pmos w=1u l=1u m=1
XT2258 vdd well_2258 ntap1 A=4e-12 P=8e-6
XM7_42 net049 net1 vdd well_2258 sg13_lv_pmos w=1u l=1u m=1
XT2259 vdd well_2259 ntap1 A=4e-12 P=8e-6
XM7_43 net049 net1 vdd well_2259 sg13_lv_pmos w=1u l=1u m=1
XT2260 vdd well_2260 ntap1 A=4e-12 P=8e-6
XM7_44 net049 net1 vdd well_2260 sg13_lv_pmos w=1u l=1u m=1
XT2261 vdd well_2261 ntap1 A=4e-12 P=8e-6
XM7_45 net049 net1 vdd well_2261 sg13_lv_pmos w=1u l=1u m=1
XT2262 vdd well_2262 ntap1 A=4e-12 P=8e-6
XM7_46 net049 net1 vdd well_2262 sg13_lv_pmos w=1u l=1u m=1
XT2263 vdd well_2263 ntap1 A=4e-12 P=8e-6
XM7_47 net049 net1 vdd well_2263 sg13_lv_pmos w=1u l=1u m=1
XT2264 vdd well_2264 ntap1 A=4e-12 P=8e-6
XM7_48 net049 net1 vdd well_2264 sg13_lv_pmos w=1u l=1u m=1
XT2265 vdd well_2265 ntap1 A=4e-12 P=8e-6
XM7_49 net049 net1 vdd well_2265 sg13_lv_pmos w=1u l=1u m=1
XT2266 vdd well_2266 ntap1 A=4e-12 P=8e-6
XM7_50 net049 net1 vdd well_2266 sg13_lv_pmos w=1u l=1u m=1
XT2267 vdd well_2267 ntap1 A=4e-12 P=8e-6
XM7_51 net049 net1 vdd well_2267 sg13_lv_pmos w=1u l=1u m=1
XT2268 vdd well_2268 ntap1 A=4e-12 P=8e-6
XM7_52 net049 net1 vdd well_2268 sg13_lv_pmos w=1u l=1u m=1
XT2269 vdd well_2269 ntap1 A=4e-12 P=8e-6
XM7_53 net049 net1 vdd well_2269 sg13_lv_pmos w=1u l=1u m=1
XT2270 vdd well_2270 ntap1 A=4e-12 P=8e-6
XM7_54 net049 net1 vdd well_2270 sg13_lv_pmos w=1u l=1u m=1
XT2271 vdd well_2271 ntap1 A=4e-12 P=8e-6
XM7_55 net049 net1 vdd well_2271 sg13_lv_pmos w=1u l=1u m=1
XT2272 vdd well_2272 ntap1 A=4e-12 P=8e-6
XM7_56 net049 net1 vdd well_2272 sg13_lv_pmos w=1u l=1u m=1
XT2273 vdd well_2273 ntap1 A=4e-12 P=8e-6
XM7_57 net049 net1 vdd well_2273 sg13_lv_pmos w=1u l=1u m=1
XT2274 vdd well_2274 ntap1 A=4e-12 P=8e-6
XM7_58 net049 net1 vdd well_2274 sg13_lv_pmos w=1u l=1u m=1
XT2275 vdd well_2275 ntap1 A=4e-12 P=8e-6
XM7_59 net049 net1 vdd well_2275 sg13_lv_pmos w=1u l=1u m=1
XT2276 vdd well_2276 ntap1 A=4e-12 P=8e-6
XM7_60 net049 net1 vdd well_2276 sg13_lv_pmos w=1u l=1u m=1
XT2277 vdd well_2277 ntap1 A=4e-12 P=8e-6
XM7_61 net049 net1 vdd well_2277 sg13_lv_pmos w=1u l=1u m=1
XT2278 vdd well_2278 ntap1 A=4e-12 P=8e-6
XM7_62 net049 net1 vdd well_2278 sg13_lv_pmos w=1u l=1u m=1
XT2279 vdd well_2279 ntap1 A=4e-12 P=8e-6
XM7_63 net049 net1 vdd well_2279 sg13_lv_pmos w=1u l=1u m=1
XT2280 vdd well_2280 ntap1 A=4e-12 P=8e-6
XM7_64 net049 net1 vdd well_2280 sg13_lv_pmos w=1u l=1u m=1
XT2281 vdd well_2281 ntap1 A=4e-12 P=8e-6
XM7_65 net049 net1 vdd well_2281 sg13_lv_pmos w=1u l=1u m=1
XT2282 vdd well_2282 ntap1 A=4e-12 P=8e-6
XM7_66 net049 net1 vdd well_2282 sg13_lv_pmos w=1u l=1u m=1
XT2283 vdd well_2283 ntap1 A=4e-12 P=8e-6
XM7_67 net049 net1 vdd well_2283 sg13_lv_pmos w=1u l=1u m=1
XT2284 vdd well_2284 ntap1 A=4e-12 P=8e-6
XM7_68 net049 net1 vdd well_2284 sg13_lv_pmos w=1u l=1u m=1
XT2285 vdd well_2285 ntap1 A=4e-12 P=8e-6
XM7_69 net049 net1 vdd well_2285 sg13_lv_pmos w=1u l=1u m=1
XT2286 vdd well_2286 ntap1 A=4e-12 P=8e-6
XM7_70 net049 net1 vdd well_2286 sg13_lv_pmos w=1u l=1u m=1
XT2287 net31 well_2287 ntap1 A=4e-12 P=8e-6
XM8_0 dm_2 vinn net31 well_2287 sg13_lv_pmos w=1u l=1u m=1
XT2288 net31 well_2288 ntap1 A=4e-12 P=8e-6
XM8_1 dm_2 vinn net31 well_2288 sg13_lv_pmos w=1u l=1u m=1
XT2289 net31 well_2289 ntap1 A=4e-12 P=8e-6
XM8_2 dm_2 vinn net31 well_2289 sg13_lv_pmos w=1u l=1u m=1
XT2290 net31 well_2290 ntap1 A=4e-12 P=8e-6
XM8_3 dm_2 vinn net31 well_2290 sg13_lv_pmos w=1u l=1u m=1
XT2291 net31 well_2291 ntap1 A=4e-12 P=8e-6
XM8_4 dm_2 vinn net31 well_2291 sg13_lv_pmos w=1u l=1u m=1
XT2292 net31 well_2292 ntap1 A=4e-12 P=8e-6
XM8_5 dm_2 vinn net31 well_2292 sg13_lv_pmos w=1u l=1u m=1
XT2293 net31 well_2293 ntap1 A=4e-12 P=8e-6
XM8_6 dm_2 vinn net31 well_2293 sg13_lv_pmos w=1u l=1u m=1
XT2294 net31 well_2294 ntap1 A=4e-12 P=8e-6
XM8_7 dm_2 vinn net31 well_2294 sg13_lv_pmos w=1u l=1u m=1
XT2295 net31 well_2295 ntap1 A=4e-12 P=8e-6
XM8_8 dm_2 vinn net31 well_2295 sg13_lv_pmos w=1u l=1u m=1
XT2296 net31 well_2296 ntap1 A=4e-12 P=8e-6
XM8_9 dm_2 vinn net31 well_2296 sg13_lv_pmos w=1u l=1u m=1
XT2297 net31 well_2297 ntap1 A=4e-12 P=8e-6
XM8_10 dm_2 vinn net31 well_2297 sg13_lv_pmos w=1u l=1u m=1
XT2298 net31 well_2298 ntap1 A=4e-12 P=8e-6
XM8_11 dm_2 vinn net31 well_2298 sg13_lv_pmos w=1u l=1u m=1
XT2299 net31 well_2299 ntap1 A=4e-12 P=8e-6
XM8_12 dm_2 vinn net31 well_2299 sg13_lv_pmos w=1u l=1u m=1
XT2300 net31 well_2300 ntap1 A=4e-12 P=8e-6
XM8_13 dm_2 vinn net31 well_2300 sg13_lv_pmos w=1u l=1u m=1
XT2301 net31 well_2301 ntap1 A=4e-12 P=8e-6
XM8_14 dm_2 vinn net31 well_2301 sg13_lv_pmos w=1u l=1u m=1
XT2302 net31 well_2302 ntap1 A=4e-12 P=8e-6
XM8_15 dm_2 vinn net31 well_2302 sg13_lv_pmos w=1u l=1u m=1
XT2303 net31 well_2303 ntap1 A=4e-12 P=8e-6
XM8_16 dm_2 vinn net31 well_2303 sg13_lv_pmos w=1u l=1u m=1
XT2304 net31 well_2304 ntap1 A=4e-12 P=8e-6
XM8_17 dm_2 vinn net31 well_2304 sg13_lv_pmos w=1u l=1u m=1
XT2305 net31 well_2305 ntap1 A=4e-12 P=8e-6
XM8_18 dm_2 vinn net31 well_2305 sg13_lv_pmos w=1u l=1u m=1
XT2306 net31 well_2306 ntap1 A=4e-12 P=8e-6
XM8_19 dm_2 vinn net31 well_2306 sg13_lv_pmos w=1u l=1u m=1
XT2307 net31 well_2307 ntap1 A=4e-12 P=8e-6
XM8_20 dm_2 vinn net31 well_2307 sg13_lv_pmos w=1u l=1u m=1
XT2308 net31 well_2308 ntap1 A=4e-12 P=8e-6
XM8_21 dm_2 vinn net31 well_2308 sg13_lv_pmos w=1u l=1u m=1
XT2309 net31 well_2309 ntap1 A=4e-12 P=8e-6
XM8_22 dm_2 vinn net31 well_2309 sg13_lv_pmos w=1u l=1u m=1
XT2310 net31 well_2310 ntap1 A=4e-12 P=8e-6
XM8_23 dm_2 vinn net31 well_2310 sg13_lv_pmos w=1u l=1u m=1
XT2311 net31 well_2311 ntap1 A=4e-12 P=8e-6
XM8_24 dm_2 vinn net31 well_2311 sg13_lv_pmos w=1u l=1u m=1
XT2312 net31 well_2312 ntap1 A=4e-12 P=8e-6
XM8_25 dm_2 vinn net31 well_2312 sg13_lv_pmos w=1u l=1u m=1
XT2313 net31 well_2313 ntap1 A=4e-12 P=8e-6
XM8_26 dm_2 vinn net31 well_2313 sg13_lv_pmos w=1u l=1u m=1
XT2314 net31 well_2314 ntap1 A=4e-12 P=8e-6
XM8_27 dm_2 vinn net31 well_2314 sg13_lv_pmos w=1u l=1u m=1
XT2315 net31 well_2315 ntap1 A=4e-12 P=8e-6
XM8_28 dm_2 vinn net31 well_2315 sg13_lv_pmos w=1u l=1u m=1
XT2316 net31 well_2316 ntap1 A=4e-12 P=8e-6
XM8_29 dm_2 vinn net31 well_2316 sg13_lv_pmos w=1u l=1u m=1
XT2317 net31 well_2317 ntap1 A=4e-12 P=8e-6
XM8_30 dm_2 vinn net31 well_2317 sg13_lv_pmos w=1u l=1u m=1
XT2318 net31 well_2318 ntap1 A=4e-12 P=8e-6
XM8_31 dm_2 vinn net31 well_2318 sg13_lv_pmos w=1u l=1u m=1
XT2319 net31 well_2319 ntap1 A=4e-12 P=8e-6
XM8_32 dm_2 vinn net31 well_2319 sg13_lv_pmos w=1u l=1u m=1
XT2320 net31 well_2320 ntap1 A=4e-12 P=8e-6
XM8_33 dm_2 vinn net31 well_2320 sg13_lv_pmos w=1u l=1u m=1
XT2321 net31 well_2321 ntap1 A=4e-12 P=8e-6
XM8_34 dm_2 vinn net31 well_2321 sg13_lv_pmos w=1u l=1u m=1
XT2322 net31 well_2322 ntap1 A=4e-12 P=8e-6
XM8_35 dm_2 vinn net31 well_2322 sg13_lv_pmos w=1u l=1u m=1
XT2323 net31 well_2323 ntap1 A=4e-12 P=8e-6
XM8_36 dm_2 vinn net31 well_2323 sg13_lv_pmos w=1u l=1u m=1
XT2324 net31 well_2324 ntap1 A=4e-12 P=8e-6
XM8_37 dm_2 vinn net31 well_2324 sg13_lv_pmos w=1u l=1u m=1
XT2325 net31 well_2325 ntap1 A=4e-12 P=8e-6
XM8_38 dm_2 vinn net31 well_2325 sg13_lv_pmos w=1u l=1u m=1
XT2326 net31 well_2326 ntap1 A=4e-12 P=8e-6
XM8_39 dm_2 vinn net31 well_2326 sg13_lv_pmos w=1u l=1u m=1
XT2327 net31 well_2327 ntap1 A=4e-12 P=8e-6
XM8_40 dm_2 vinn net31 well_2327 sg13_lv_pmos w=1u l=1u m=1
XT2328 net31 well_2328 ntap1 A=4e-12 P=8e-6
XM8_41 dm_2 vinn net31 well_2328 sg13_lv_pmos w=1u l=1u m=1
XT2329 net31 well_2329 ntap1 A=4e-12 P=8e-6
XM8_42 dm_2 vinn net31 well_2329 sg13_lv_pmos w=1u l=1u m=1
XT2330 net31 well_2330 ntap1 A=4e-12 P=8e-6
XM8_43 dm_2 vinn net31 well_2330 sg13_lv_pmos w=1u l=1u m=1
XT2331 net31 well_2331 ntap1 A=4e-12 P=8e-6
XM8_44 dm_2 vinn net31 well_2331 sg13_lv_pmos w=1u l=1u m=1
XT2332 net31 well_2332 ntap1 A=4e-12 P=8e-6
XM8_45 dm_2 vinn net31 well_2332 sg13_lv_pmos w=1u l=1u m=1
XT2333 net31 well_2333 ntap1 A=4e-12 P=8e-6
XM8_46 dm_2 vinn net31 well_2333 sg13_lv_pmos w=1u l=1u m=1
XT2334 net31 well_2334 ntap1 A=4e-12 P=8e-6
XM8_47 dm_2 vinn net31 well_2334 sg13_lv_pmos w=1u l=1u m=1
XT2335 net31 well_2335 ntap1 A=4e-12 P=8e-6
XM8_48 dm_2 vinn net31 well_2335 sg13_lv_pmos w=1u l=1u m=1
XT2336 net31 well_2336 ntap1 A=4e-12 P=8e-6
XM8_49 dm_2 vinn net31 well_2336 sg13_lv_pmos w=1u l=1u m=1
XT2337 net31 well_2337 ntap1 A=4e-12 P=8e-6
XM8_50 dm_2 vinn net31 well_2337 sg13_lv_pmos w=1u l=1u m=1
XT2338 net31 well_2338 ntap1 A=4e-12 P=8e-6
XM8_51 dm_2 vinn net31 well_2338 sg13_lv_pmos w=1u l=1u m=1
XT2339 net31 well_2339 ntap1 A=4e-12 P=8e-6
XM8_52 dm_2 vinn net31 well_2339 sg13_lv_pmos w=1u l=1u m=1
XT2340 net31 well_2340 ntap1 A=4e-12 P=8e-6
XM8_53 dm_2 vinn net31 well_2340 sg13_lv_pmos w=1u l=1u m=1
XT2341 net31 well_2341 ntap1 A=4e-12 P=8e-6
XM8_54 dm_2 vinn net31 well_2341 sg13_lv_pmos w=1u l=1u m=1
XT2342 net31 well_2342 ntap1 A=4e-12 P=8e-6
XM8_55 dm_2 vinn net31 well_2342 sg13_lv_pmos w=1u l=1u m=1
XT2343 net31 well_2343 ntap1 A=4e-12 P=8e-6
XM8_56 dm_2 vinn net31 well_2343 sg13_lv_pmos w=1u l=1u m=1
XT2344 net31 well_2344 ntap1 A=4e-12 P=8e-6
XM8_57 dm_2 vinn net31 well_2344 sg13_lv_pmos w=1u l=1u m=1
XT2345 net31 well_2345 ntap1 A=4e-12 P=8e-6
XM8_58 dm_2 vinn net31 well_2345 sg13_lv_pmos w=1u l=1u m=1
XT2346 net31 well_2346 ntap1 A=4e-12 P=8e-6
XM8_59 dm_2 vinn net31 well_2346 sg13_lv_pmos w=1u l=1u m=1
XT2347 net31 well_2347 ntap1 A=4e-12 P=8e-6
XM8_60 dm_2 vinn net31 well_2347 sg13_lv_pmos w=1u l=1u m=1
XT2348 net31 well_2348 ntap1 A=4e-12 P=8e-6
XM8_61 dm_2 vinn net31 well_2348 sg13_lv_pmos w=1u l=1u m=1
XT2349 net31 well_2349 ntap1 A=4e-12 P=8e-6
XM8_62 dm_2 vinn net31 well_2349 sg13_lv_pmos w=1u l=1u m=1
XT2350 net31 well_2350 ntap1 A=4e-12 P=8e-6
XM8_63 dm_2 vinn net31 well_2350 sg13_lv_pmos w=1u l=1u m=1
XT2351 net31 well_2351 ntap1 A=4e-12 P=8e-6
XM8_64 dm_2 vinn net31 well_2351 sg13_lv_pmos w=1u l=1u m=1
XT2352 net31 well_2352 ntap1 A=4e-12 P=8e-6
XM8_65 dm_2 vinn net31 well_2352 sg13_lv_pmos w=1u l=1u m=1
XT2353 net31 well_2353 ntap1 A=4e-12 P=8e-6
XM8_66 dm_2 vinn net31 well_2353 sg13_lv_pmos w=1u l=1u m=1
XT2354 net31 well_2354 ntap1 A=4e-12 P=8e-6
XM8_67 dm_2 vinn net31 well_2354 sg13_lv_pmos w=1u l=1u m=1
XT2355 net31 well_2355 ntap1 A=4e-12 P=8e-6
XM8_68 dm_2 vinn net31 well_2355 sg13_lv_pmos w=1u l=1u m=1
XT2356 net31 well_2356 ntap1 A=4e-12 P=8e-6
XM8_69 dm_2 vinn net31 well_2356 sg13_lv_pmos w=1u l=1u m=1
XT2357 net31 well_2357 ntap1 A=4e-12 P=8e-6
XM8_70 dm_2 vinn net31 well_2357 sg13_lv_pmos w=1u l=1u m=1
XT2358 net31 well_2358 ntap1 A=4e-12 P=8e-6
XM8_71 dm_2 vinn net31 well_2358 sg13_lv_pmos w=1u l=1u m=1
XT2359 net31 well_2359 ntap1 A=4e-12 P=8e-6
XM8_72 dm_2 vinn net31 well_2359 sg13_lv_pmos w=1u l=1u m=1
XT2360 net31 well_2360 ntap1 A=4e-12 P=8e-6
XM8_73 dm_2 vinn net31 well_2360 sg13_lv_pmos w=1u l=1u m=1
XT2361 net31 well_2361 ntap1 A=4e-12 P=8e-6
XM8_74 dm_2 vinn net31 well_2361 sg13_lv_pmos w=1u l=1u m=1
XT2362 net31 well_2362 ntap1 A=4e-12 P=8e-6
XM8_75 dm_2 vinn net31 well_2362 sg13_lv_pmos w=1u l=1u m=1
XT2363 net31 well_2363 ntap1 A=4e-12 P=8e-6
XM8_76 dm_2 vinn net31 well_2363 sg13_lv_pmos w=1u l=1u m=1
XT2364 net31 well_2364 ntap1 A=4e-12 P=8e-6
XM8_77 dm_2 vinn net31 well_2364 sg13_lv_pmos w=1u l=1u m=1
XT2365 net31 well_2365 ntap1 A=4e-12 P=8e-6
XM8_78 dm_2 vinn net31 well_2365 sg13_lv_pmos w=1u l=1u m=1
XT2366 net31 well_2366 ntap1 A=4e-12 P=8e-6
XM8_79 dm_2 vinn net31 well_2366 sg13_lv_pmos w=1u l=1u m=1
XT2367 net31 well_2367 ntap1 A=4e-12 P=8e-6
XM8_80 dm_2 vinn net31 well_2367 sg13_lv_pmos w=1u l=1u m=1
XT2368 net31 well_2368 ntap1 A=4e-12 P=8e-6
XM8_81 dm_2 vinn net31 well_2368 sg13_lv_pmos w=1u l=1u m=1
XT2369 net31 well_2369 ntap1 A=4e-12 P=8e-6
XM8_82 dm_2 vinn net31 well_2369 sg13_lv_pmos w=1u l=1u m=1
XT2370 net31 well_2370 ntap1 A=4e-12 P=8e-6
XM8_83 dm_2 vinn net31 well_2370 sg13_lv_pmos w=1u l=1u m=1
XT2371 net31 well_2371 ntap1 A=4e-12 P=8e-6
XM8_84 dm_2 vinn net31 well_2371 sg13_lv_pmos w=1u l=1u m=1
XT2372 net31 well_2372 ntap1 A=4e-12 P=8e-6
XM8_85 dm_2 vinn net31 well_2372 sg13_lv_pmos w=1u l=1u m=1
XT2373 net31 well_2373 ntap1 A=4e-12 P=8e-6
XM8_86 dm_2 vinn net31 well_2373 sg13_lv_pmos w=1u l=1u m=1
XT2374 net31 well_2374 ntap1 A=4e-12 P=8e-6
XM8_87 dm_2 vinn net31 well_2374 sg13_lv_pmos w=1u l=1u m=1
XT2375 net31 well_2375 ntap1 A=4e-12 P=8e-6
XM8_88 dm_2 vinn net31 well_2375 sg13_lv_pmos w=1u l=1u m=1
XT2376 net31 well_2376 ntap1 A=4e-12 P=8e-6
XM8_89 dm_2 vinn net31 well_2376 sg13_lv_pmos w=1u l=1u m=1
XT2377 net31 well_2377 ntap1 A=4e-12 P=8e-6
XM8_90 dm_2 vinn net31 well_2377 sg13_lv_pmos w=1u l=1u m=1
XT2378 net31 well_2378 ntap1 A=4e-12 P=8e-6
XM8_91 dm_2 vinn net31 well_2378 sg13_lv_pmos w=1u l=1u m=1
XT2379 net31 well_2379 ntap1 A=4e-12 P=8e-6
XM8_92 dm_2 vinn net31 well_2379 sg13_lv_pmos w=1u l=1u m=1
XT2380 net31 well_2380 ntap1 A=4e-12 P=8e-6
XM8_93 dm_2 vinn net31 well_2380 sg13_lv_pmos w=1u l=1u m=1
XT2381 net31 well_2381 ntap1 A=4e-12 P=8e-6
XM8_94 dm_2 vinn net31 well_2381 sg13_lv_pmos w=1u l=1u m=1
XT2382 net31 well_2382 ntap1 A=4e-12 P=8e-6
XM8_95 dm_2 vinn net31 well_2382 sg13_lv_pmos w=1u l=1u m=1
XT2383 net31 well_2383 ntap1 A=4e-12 P=8e-6
XM8_96 dm_2 vinn net31 well_2383 sg13_lv_pmos w=1u l=1u m=1
XT2384 net31 well_2384 ntap1 A=4e-12 P=8e-6
XM8_97 dm_2 vinn net31 well_2384 sg13_lv_pmos w=1u l=1u m=1
XT2385 net31 well_2385 ntap1 A=4e-12 P=8e-6
XM8_98 dm_2 vinn net31 well_2385 sg13_lv_pmos w=1u l=1u m=1
XT2386 net31 well_2386 ntap1 A=4e-12 P=8e-6
XM8_99 dm_2 vinn net31 well_2386 sg13_lv_pmos w=1u l=1u m=1
XT2387 net31 well_2387 ntap1 A=4e-12 P=8e-6
XM8_100 dm_2 vinn net31 well_2387 sg13_lv_pmos w=1u l=1u m=1
XT2388 net31 well_2388 ntap1 A=4e-12 P=8e-6
XM8_101 dm_2 vinn net31 well_2388 sg13_lv_pmos w=1u l=1u m=1
XT2389 net31 well_2389 ntap1 A=4e-12 P=8e-6
XM8_102 dm_2 vinn net31 well_2389 sg13_lv_pmos w=1u l=1u m=1
XT2390 net31 well_2390 ntap1 A=4e-12 P=8e-6
XM8_103 dm_2 vinn net31 well_2390 sg13_lv_pmos w=1u l=1u m=1
XT2391 net31 well_2391 ntap1 A=4e-12 P=8e-6
XM8_104 dm_2 vinn net31 well_2391 sg13_lv_pmos w=1u l=1u m=1
XT2392 net31 well_2392 ntap1 A=4e-12 P=8e-6
XM8_105 dm_2 vinn net31 well_2392 sg13_lv_pmos w=1u l=1u m=1
XT2393 net31 well_2393 ntap1 A=4e-12 P=8e-6
XM8_106 dm_2 vinn net31 well_2393 sg13_lv_pmos w=1u l=1u m=1
XT2394 net31 well_2394 ntap1 A=4e-12 P=8e-6
XM8_107 dm_2 vinn net31 well_2394 sg13_lv_pmos w=1u l=1u m=1
XT2395 net31 well_2395 ntap1 A=4e-12 P=8e-6
XM8_108 dm_2 vinn net31 well_2395 sg13_lv_pmos w=1u l=1u m=1
XT2396 net31 well_2396 ntap1 A=4e-12 P=8e-6
XM8_109 dm_2 vinn net31 well_2396 sg13_lv_pmos w=1u l=1u m=1
XT2397 net31 well_2397 ntap1 A=4e-12 P=8e-6
XM8_110 dm_2 vinn net31 well_2397 sg13_lv_pmos w=1u l=1u m=1
XT2398 net31 well_2398 ntap1 A=4e-12 P=8e-6
XM8_111 dm_2 vinn net31 well_2398 sg13_lv_pmos w=1u l=1u m=1
XT2399 net31 well_2399 ntap1 A=4e-12 P=8e-6
XM8_112 dm_2 vinn net31 well_2399 sg13_lv_pmos w=1u l=1u m=1
XT2400 net31 well_2400 ntap1 A=4e-12 P=8e-6
XM8_113 dm_2 vinn net31 well_2400 sg13_lv_pmos w=1u l=1u m=1
XT2401 net31 well_2401 ntap1 A=4e-12 P=8e-6
XM8_114 dm_2 vinn net31 well_2401 sg13_lv_pmos w=1u l=1u m=1
XT2402 net31 well_2402 ntap1 A=4e-12 P=8e-6
XM8_115 dm_2 vinn net31 well_2402 sg13_lv_pmos w=1u l=1u m=1
XT2403 net31 well_2403 ntap1 A=4e-12 P=8e-6
XM8_116 dm_2 vinn net31 well_2403 sg13_lv_pmos w=1u l=1u m=1
XT2404 net31 well_2404 ntap1 A=4e-12 P=8e-6
XM8_117 dm_2 vinn net31 well_2404 sg13_lv_pmos w=1u l=1u m=1
XT2405 net31 well_2405 ntap1 A=4e-12 P=8e-6
XM8_118 dm_2 vinn net31 well_2405 sg13_lv_pmos w=1u l=1u m=1
XT2406 net31 well_2406 ntap1 A=4e-12 P=8e-6
XM8_119 dm_2 vinn net31 well_2406 sg13_lv_pmos w=1u l=1u m=1
XT2407 net31 well_2407 ntap1 A=4e-12 P=8e-6
XM8_120 dm_2 vinn net31 well_2407 sg13_lv_pmos w=1u l=1u m=1
XT2408 net31 well_2408 ntap1 A=4e-12 P=8e-6
XM8_121 dm_2 vinn net31 well_2408 sg13_lv_pmos w=1u l=1u m=1
XT2409 net31 well_2409 ntap1 A=4e-12 P=8e-6
XM8_122 dm_2 vinn net31 well_2409 sg13_lv_pmos w=1u l=1u m=1
XT2410 net31 well_2410 ntap1 A=4e-12 P=8e-6
XM8_123 dm_2 vinn net31 well_2410 sg13_lv_pmos w=1u l=1u m=1
XT2411 net31 well_2411 ntap1 A=4e-12 P=8e-6
XM8_124 dm_2 vinn net31 well_2411 sg13_lv_pmos w=1u l=1u m=1
XT2412 net31 well_2412 ntap1 A=4e-12 P=8e-6
XM8_125 dm_2 vinn net31 well_2412 sg13_lv_pmos w=1u l=1u m=1
XT2413 net31 well_2413 ntap1 A=4e-12 P=8e-6
XM8_126 dm_2 vinn net31 well_2413 sg13_lv_pmos w=1u l=1u m=1
XT2414 net31 well_2414 ntap1 A=4e-12 P=8e-6
XM8_127 dm_2 vinn net31 well_2414 sg13_lv_pmos w=1u l=1u m=1
XT2415 net31 well_2415 ntap1 A=4e-12 P=8e-6
XM8_128 dm_2 vinn net31 well_2415 sg13_lv_pmos w=1u l=1u m=1
XT2416 net31 well_2416 ntap1 A=4e-12 P=8e-6
XM8_129 dm_2 vinn net31 well_2416 sg13_lv_pmos w=1u l=1u m=1
XT2417 net31 well_2417 ntap1 A=4e-12 P=8e-6
XM8_130 dm_2 vinn net31 well_2417 sg13_lv_pmos w=1u l=1u m=1
XT2418 net31 well_2418 ntap1 A=4e-12 P=8e-6
XM8_131 dm_2 vinn net31 well_2418 sg13_lv_pmos w=1u l=1u m=1
XT2419 net31 well_2419 ntap1 A=4e-12 P=8e-6
XM8_132 dm_2 vinn net31 well_2419 sg13_lv_pmos w=1u l=1u m=1
XT2420 net31 well_2420 ntap1 A=4e-12 P=8e-6
XM8_133 dm_2 vinn net31 well_2420 sg13_lv_pmos w=1u l=1u m=1
XT2421 net31 well_2421 ntap1 A=4e-12 P=8e-6
XM8_134 dm_2 vinn net31 well_2421 sg13_lv_pmos w=1u l=1u m=1
XT2422 net31 well_2422 ntap1 A=4e-12 P=8e-6
XM8_135 dm_2 vinn net31 well_2422 sg13_lv_pmos w=1u l=1u m=1
XT2423 net31 well_2423 ntap1 A=4e-12 P=8e-6
XM8_136 dm_2 vinn net31 well_2423 sg13_lv_pmos w=1u l=1u m=1
XT2424 net31 well_2424 ntap1 A=4e-12 P=8e-6
XM8_137 dm_2 vinn net31 well_2424 sg13_lv_pmos w=1u l=1u m=1
XT2425 net31 well_2425 ntap1 A=4e-12 P=8e-6
XM8_138 dm_2 vinn net31 well_2425 sg13_lv_pmos w=1u l=1u m=1
XT2426 net31 well_2426 ntap1 A=4e-12 P=8e-6
XM8_139 dm_2 vinn net31 well_2426 sg13_lv_pmos w=1u l=1u m=1
XT2427 net31 well_2427 ntap1 A=4e-12 P=8e-6
XM8_140 dm_2 vinn net31 well_2427 sg13_lv_pmos w=1u l=1u m=1
XT2428 net31 well_2428 ntap1 A=4e-12 P=8e-6
XM8_141 dm_2 vinn net31 well_2428 sg13_lv_pmos w=1u l=1u m=1
XT2429 net31 well_2429 ntap1 A=4e-12 P=8e-6
XM8_142 dm_2 vinn net31 well_2429 sg13_lv_pmos w=1u l=1u m=1
XT2430 net31 well_2430 ntap1 A=4e-12 P=8e-6
XM8_143 dm_2 vinn net31 well_2430 sg13_lv_pmos w=1u l=1u m=1
XT2431 net31 well_2431 ntap1 A=4e-12 P=8e-6
XM8_144 dm_2 vinn net31 well_2431 sg13_lv_pmos w=1u l=1u m=1
XT2432 net31 well_2432 ntap1 A=4e-12 P=8e-6
XM8_145 dm_2 vinn net31 well_2432 sg13_lv_pmos w=1u l=1u m=1
XT2433 net31 well_2433 ntap1 A=4e-12 P=8e-6
XM8_146 dm_2 vinn net31 well_2433 sg13_lv_pmos w=1u l=1u m=1
XT2434 net31 well_2434 ntap1 A=4e-12 P=8e-6
XM8_147 dm_2 vinn net31 well_2434 sg13_lv_pmos w=1u l=1u m=1
XT2435 net31 well_2435 ntap1 A=4e-12 P=8e-6
XM9_0 net063 vinp net31 well_2435 sg13_lv_pmos w=1u l=1u m=1
XT2436 net31 well_2436 ntap1 A=4e-12 P=8e-6
XM9_1 net063 vinp net31 well_2436 sg13_lv_pmos w=1u l=1u m=1
XT2437 net31 well_2437 ntap1 A=4e-12 P=8e-6
XM9_2 net063 vinp net31 well_2437 sg13_lv_pmos w=1u l=1u m=1
XT2438 net31 well_2438 ntap1 A=4e-12 P=8e-6
XM9_3 net063 vinp net31 well_2438 sg13_lv_pmos w=1u l=1u m=1
XT2439 net31 well_2439 ntap1 A=4e-12 P=8e-6
XM9_4 net063 vinp net31 well_2439 sg13_lv_pmos w=1u l=1u m=1
XT2440 net31 well_2440 ntap1 A=4e-12 P=8e-6
XM9_5 net063 vinp net31 well_2440 sg13_lv_pmos w=1u l=1u m=1
XT2441 net31 well_2441 ntap1 A=4e-12 P=8e-6
XM9_6 net063 vinp net31 well_2441 sg13_lv_pmos w=1u l=1u m=1
XT2442 net31 well_2442 ntap1 A=4e-12 P=8e-6
XM9_7 net063 vinp net31 well_2442 sg13_lv_pmos w=1u l=1u m=1
XT2443 net31 well_2443 ntap1 A=4e-12 P=8e-6
XM9_8 net063 vinp net31 well_2443 sg13_lv_pmos w=1u l=1u m=1
XT2444 net31 well_2444 ntap1 A=4e-12 P=8e-6
XM9_9 net063 vinp net31 well_2444 sg13_lv_pmos w=1u l=1u m=1
XT2445 net31 well_2445 ntap1 A=4e-12 P=8e-6
XM9_10 net063 vinp net31 well_2445 sg13_lv_pmos w=1u l=1u m=1
XT2446 net31 well_2446 ntap1 A=4e-12 P=8e-6
XM9_11 net063 vinp net31 well_2446 sg13_lv_pmos w=1u l=1u m=1
XT2447 net31 well_2447 ntap1 A=4e-12 P=8e-6
XM9_12 net063 vinp net31 well_2447 sg13_lv_pmos w=1u l=1u m=1
XT2448 net31 well_2448 ntap1 A=4e-12 P=8e-6
XM9_13 net063 vinp net31 well_2448 sg13_lv_pmos w=1u l=1u m=1
XT2449 net31 well_2449 ntap1 A=4e-12 P=8e-6
XM9_14 net063 vinp net31 well_2449 sg13_lv_pmos w=1u l=1u m=1
XT2450 net31 well_2450 ntap1 A=4e-12 P=8e-6
XM9_15 net063 vinp net31 well_2450 sg13_lv_pmos w=1u l=1u m=1
XT2451 net31 well_2451 ntap1 A=4e-12 P=8e-6
XM9_16 net063 vinp net31 well_2451 sg13_lv_pmos w=1u l=1u m=1
XT2452 net31 well_2452 ntap1 A=4e-12 P=8e-6
XM9_17 net063 vinp net31 well_2452 sg13_lv_pmos w=1u l=1u m=1
XT2453 net31 well_2453 ntap1 A=4e-12 P=8e-6
XM9_18 net063 vinp net31 well_2453 sg13_lv_pmos w=1u l=1u m=1
XT2454 net31 well_2454 ntap1 A=4e-12 P=8e-6
XM9_19 net063 vinp net31 well_2454 sg13_lv_pmos w=1u l=1u m=1
XT2455 net31 well_2455 ntap1 A=4e-12 P=8e-6
XM9_20 net063 vinp net31 well_2455 sg13_lv_pmos w=1u l=1u m=1
XT2456 net31 well_2456 ntap1 A=4e-12 P=8e-6
XM9_21 net063 vinp net31 well_2456 sg13_lv_pmos w=1u l=1u m=1
XT2457 net31 well_2457 ntap1 A=4e-12 P=8e-6
XM9_22 net063 vinp net31 well_2457 sg13_lv_pmos w=1u l=1u m=1
XT2458 net31 well_2458 ntap1 A=4e-12 P=8e-6
XM9_23 net063 vinp net31 well_2458 sg13_lv_pmos w=1u l=1u m=1
XT2459 net31 well_2459 ntap1 A=4e-12 P=8e-6
XM9_24 net063 vinp net31 well_2459 sg13_lv_pmos w=1u l=1u m=1
XT2460 net31 well_2460 ntap1 A=4e-12 P=8e-6
XM9_25 net063 vinp net31 well_2460 sg13_lv_pmos w=1u l=1u m=1
XT2461 net31 well_2461 ntap1 A=4e-12 P=8e-6
XM9_26 net063 vinp net31 well_2461 sg13_lv_pmos w=1u l=1u m=1
XT2462 net31 well_2462 ntap1 A=4e-12 P=8e-6
XM9_27 net063 vinp net31 well_2462 sg13_lv_pmos w=1u l=1u m=1
XT2463 net31 well_2463 ntap1 A=4e-12 P=8e-6
XM9_28 net063 vinp net31 well_2463 sg13_lv_pmos w=1u l=1u m=1
XT2464 net31 well_2464 ntap1 A=4e-12 P=8e-6
XM9_29 net063 vinp net31 well_2464 sg13_lv_pmos w=1u l=1u m=1
XT2465 net31 well_2465 ntap1 A=4e-12 P=8e-6
XM9_30 net063 vinp net31 well_2465 sg13_lv_pmos w=1u l=1u m=1
XT2466 net31 well_2466 ntap1 A=4e-12 P=8e-6
XM9_31 net063 vinp net31 well_2466 sg13_lv_pmos w=1u l=1u m=1
XT2467 net31 well_2467 ntap1 A=4e-12 P=8e-6
XM9_32 net063 vinp net31 well_2467 sg13_lv_pmos w=1u l=1u m=1
XT2468 net31 well_2468 ntap1 A=4e-12 P=8e-6
XM9_33 net063 vinp net31 well_2468 sg13_lv_pmos w=1u l=1u m=1
XT2469 net31 well_2469 ntap1 A=4e-12 P=8e-6
XM9_34 net063 vinp net31 well_2469 sg13_lv_pmos w=1u l=1u m=1
XT2470 net31 well_2470 ntap1 A=4e-12 P=8e-6
XM9_35 net063 vinp net31 well_2470 sg13_lv_pmos w=1u l=1u m=1
XT2471 net31 well_2471 ntap1 A=4e-12 P=8e-6
XM9_36 net063 vinp net31 well_2471 sg13_lv_pmos w=1u l=1u m=1
XT2472 net31 well_2472 ntap1 A=4e-12 P=8e-6
XM9_37 net063 vinp net31 well_2472 sg13_lv_pmos w=1u l=1u m=1
XT2473 net31 well_2473 ntap1 A=4e-12 P=8e-6
XM9_38 net063 vinp net31 well_2473 sg13_lv_pmos w=1u l=1u m=1
XT2474 net31 well_2474 ntap1 A=4e-12 P=8e-6
XM9_39 net063 vinp net31 well_2474 sg13_lv_pmos w=1u l=1u m=1
XT2475 net31 well_2475 ntap1 A=4e-12 P=8e-6
XM9_40 net063 vinp net31 well_2475 sg13_lv_pmos w=1u l=1u m=1
XT2476 net31 well_2476 ntap1 A=4e-12 P=8e-6
XM9_41 net063 vinp net31 well_2476 sg13_lv_pmos w=1u l=1u m=1
XT2477 net31 well_2477 ntap1 A=4e-12 P=8e-6
XM9_42 net063 vinp net31 well_2477 sg13_lv_pmos w=1u l=1u m=1
XT2478 net31 well_2478 ntap1 A=4e-12 P=8e-6
XM9_43 net063 vinp net31 well_2478 sg13_lv_pmos w=1u l=1u m=1
XT2479 net31 well_2479 ntap1 A=4e-12 P=8e-6
XM9_44 net063 vinp net31 well_2479 sg13_lv_pmos w=1u l=1u m=1
XT2480 net31 well_2480 ntap1 A=4e-12 P=8e-6
XM9_45 net063 vinp net31 well_2480 sg13_lv_pmos w=1u l=1u m=1
XT2481 net31 well_2481 ntap1 A=4e-12 P=8e-6
XM9_46 net063 vinp net31 well_2481 sg13_lv_pmos w=1u l=1u m=1
XT2482 net31 well_2482 ntap1 A=4e-12 P=8e-6
XM9_47 net063 vinp net31 well_2482 sg13_lv_pmos w=1u l=1u m=1
XT2483 net31 well_2483 ntap1 A=4e-12 P=8e-6
XM9_48 net063 vinp net31 well_2483 sg13_lv_pmos w=1u l=1u m=1
XT2484 net31 well_2484 ntap1 A=4e-12 P=8e-6
XM9_49 net063 vinp net31 well_2484 sg13_lv_pmos w=1u l=1u m=1
XT2485 net31 well_2485 ntap1 A=4e-12 P=8e-6
XM9_50 net063 vinp net31 well_2485 sg13_lv_pmos w=1u l=1u m=1
XT2486 net31 well_2486 ntap1 A=4e-12 P=8e-6
XM9_51 net063 vinp net31 well_2486 sg13_lv_pmos w=1u l=1u m=1
XT2487 net31 well_2487 ntap1 A=4e-12 P=8e-6
XM9_52 net063 vinp net31 well_2487 sg13_lv_pmos w=1u l=1u m=1
XT2488 net31 well_2488 ntap1 A=4e-12 P=8e-6
XM9_53 net063 vinp net31 well_2488 sg13_lv_pmos w=1u l=1u m=1
XT2489 net31 well_2489 ntap1 A=4e-12 P=8e-6
XM9_54 net063 vinp net31 well_2489 sg13_lv_pmos w=1u l=1u m=1
XT2490 net31 well_2490 ntap1 A=4e-12 P=8e-6
XM9_55 net063 vinp net31 well_2490 sg13_lv_pmos w=1u l=1u m=1
XT2491 net31 well_2491 ntap1 A=4e-12 P=8e-6
XM9_56 net063 vinp net31 well_2491 sg13_lv_pmos w=1u l=1u m=1
XT2492 net31 well_2492 ntap1 A=4e-12 P=8e-6
XM9_57 net063 vinp net31 well_2492 sg13_lv_pmos w=1u l=1u m=1
XT2493 net31 well_2493 ntap1 A=4e-12 P=8e-6
XM9_58 net063 vinp net31 well_2493 sg13_lv_pmos w=1u l=1u m=1
XT2494 net31 well_2494 ntap1 A=4e-12 P=8e-6
XM9_59 net063 vinp net31 well_2494 sg13_lv_pmos w=1u l=1u m=1
XT2495 net31 well_2495 ntap1 A=4e-12 P=8e-6
XM9_60 net063 vinp net31 well_2495 sg13_lv_pmos w=1u l=1u m=1
XT2496 net31 well_2496 ntap1 A=4e-12 P=8e-6
XM9_61 net063 vinp net31 well_2496 sg13_lv_pmos w=1u l=1u m=1
XT2497 net31 well_2497 ntap1 A=4e-12 P=8e-6
XM9_62 net063 vinp net31 well_2497 sg13_lv_pmos w=1u l=1u m=1
XT2498 net31 well_2498 ntap1 A=4e-12 P=8e-6
XM9_63 net063 vinp net31 well_2498 sg13_lv_pmos w=1u l=1u m=1
XT2499 net31 well_2499 ntap1 A=4e-12 P=8e-6
XM9_64 net063 vinp net31 well_2499 sg13_lv_pmos w=1u l=1u m=1
XT2500 net31 well_2500 ntap1 A=4e-12 P=8e-6
XM9_65 net063 vinp net31 well_2500 sg13_lv_pmos w=1u l=1u m=1
XT2501 net31 well_2501 ntap1 A=4e-12 P=8e-6
XM9_66 net063 vinp net31 well_2501 sg13_lv_pmos w=1u l=1u m=1
XT2502 net31 well_2502 ntap1 A=4e-12 P=8e-6
XM9_67 net063 vinp net31 well_2502 sg13_lv_pmos w=1u l=1u m=1
XT2503 net31 well_2503 ntap1 A=4e-12 P=8e-6
XM9_68 net063 vinp net31 well_2503 sg13_lv_pmos w=1u l=1u m=1
XT2504 net31 well_2504 ntap1 A=4e-12 P=8e-6
XM9_69 net063 vinp net31 well_2504 sg13_lv_pmos w=1u l=1u m=1
XT2505 net31 well_2505 ntap1 A=4e-12 P=8e-6
XM9_70 net063 vinp net31 well_2505 sg13_lv_pmos w=1u l=1u m=1
XT2506 net31 well_2506 ntap1 A=4e-12 P=8e-6
XM9_71 net063 vinp net31 well_2506 sg13_lv_pmos w=1u l=1u m=1
XT2507 net31 well_2507 ntap1 A=4e-12 P=8e-6
XM9_72 net063 vinp net31 well_2507 sg13_lv_pmos w=1u l=1u m=1
XT2508 net31 well_2508 ntap1 A=4e-12 P=8e-6
XM9_73 net063 vinp net31 well_2508 sg13_lv_pmos w=1u l=1u m=1
XT2509 net31 well_2509 ntap1 A=4e-12 P=8e-6
XM9_74 net063 vinp net31 well_2509 sg13_lv_pmos w=1u l=1u m=1
XT2510 net31 well_2510 ntap1 A=4e-12 P=8e-6
XM9_75 net063 vinp net31 well_2510 sg13_lv_pmos w=1u l=1u m=1
XT2511 net31 well_2511 ntap1 A=4e-12 P=8e-6
XM9_76 net063 vinp net31 well_2511 sg13_lv_pmos w=1u l=1u m=1
XT2512 net31 well_2512 ntap1 A=4e-12 P=8e-6
XM9_77 net063 vinp net31 well_2512 sg13_lv_pmos w=1u l=1u m=1
XT2513 net31 well_2513 ntap1 A=4e-12 P=8e-6
XM9_78 net063 vinp net31 well_2513 sg13_lv_pmos w=1u l=1u m=1
XT2514 net31 well_2514 ntap1 A=4e-12 P=8e-6
XM9_79 net063 vinp net31 well_2514 sg13_lv_pmos w=1u l=1u m=1
XT2515 net31 well_2515 ntap1 A=4e-12 P=8e-6
XM9_80 net063 vinp net31 well_2515 sg13_lv_pmos w=1u l=1u m=1
XT2516 net31 well_2516 ntap1 A=4e-12 P=8e-6
XM9_81 net063 vinp net31 well_2516 sg13_lv_pmos w=1u l=1u m=1
XT2517 net31 well_2517 ntap1 A=4e-12 P=8e-6
XM9_82 net063 vinp net31 well_2517 sg13_lv_pmos w=1u l=1u m=1
XT2518 net31 well_2518 ntap1 A=4e-12 P=8e-6
XM9_83 net063 vinp net31 well_2518 sg13_lv_pmos w=1u l=1u m=1
XT2519 net31 well_2519 ntap1 A=4e-12 P=8e-6
XM9_84 net063 vinp net31 well_2519 sg13_lv_pmos w=1u l=1u m=1
XT2520 net31 well_2520 ntap1 A=4e-12 P=8e-6
XM9_85 net063 vinp net31 well_2520 sg13_lv_pmos w=1u l=1u m=1
XT2521 net31 well_2521 ntap1 A=4e-12 P=8e-6
XM9_86 net063 vinp net31 well_2521 sg13_lv_pmos w=1u l=1u m=1
XT2522 net31 well_2522 ntap1 A=4e-12 P=8e-6
XM9_87 net063 vinp net31 well_2522 sg13_lv_pmos w=1u l=1u m=1
XT2523 net31 well_2523 ntap1 A=4e-12 P=8e-6
XM9_88 net063 vinp net31 well_2523 sg13_lv_pmos w=1u l=1u m=1
XT2524 net31 well_2524 ntap1 A=4e-12 P=8e-6
XM9_89 net063 vinp net31 well_2524 sg13_lv_pmos w=1u l=1u m=1
XT2525 net31 well_2525 ntap1 A=4e-12 P=8e-6
XM9_90 net063 vinp net31 well_2525 sg13_lv_pmos w=1u l=1u m=1
XT2526 net31 well_2526 ntap1 A=4e-12 P=8e-6
XM9_91 net063 vinp net31 well_2526 sg13_lv_pmos w=1u l=1u m=1
XT2527 net31 well_2527 ntap1 A=4e-12 P=8e-6
XM9_92 net063 vinp net31 well_2527 sg13_lv_pmos w=1u l=1u m=1
XT2528 net31 well_2528 ntap1 A=4e-12 P=8e-6
XM9_93 net063 vinp net31 well_2528 sg13_lv_pmos w=1u l=1u m=1
XT2529 net31 well_2529 ntap1 A=4e-12 P=8e-6
XM9_94 net063 vinp net31 well_2529 sg13_lv_pmos w=1u l=1u m=1
XT2530 net31 well_2530 ntap1 A=4e-12 P=8e-6
XM9_95 net063 vinp net31 well_2530 sg13_lv_pmos w=1u l=1u m=1
XT2531 net31 well_2531 ntap1 A=4e-12 P=8e-6
XM9_96 net063 vinp net31 well_2531 sg13_lv_pmos w=1u l=1u m=1
XT2532 net31 well_2532 ntap1 A=4e-12 P=8e-6
XM9_97 net063 vinp net31 well_2532 sg13_lv_pmos w=1u l=1u m=1
XT2533 net31 well_2533 ntap1 A=4e-12 P=8e-6
XM9_98 net063 vinp net31 well_2533 sg13_lv_pmos w=1u l=1u m=1
XT2534 net31 well_2534 ntap1 A=4e-12 P=8e-6
XM9_99 net063 vinp net31 well_2534 sg13_lv_pmos w=1u l=1u m=1
XT2535 net31 well_2535 ntap1 A=4e-12 P=8e-6
XM9_100 net063 vinp net31 well_2535 sg13_lv_pmos w=1u l=1u m=1
XT2536 net31 well_2536 ntap1 A=4e-12 P=8e-6
XM9_101 net063 vinp net31 well_2536 sg13_lv_pmos w=1u l=1u m=1
XT2537 net31 well_2537 ntap1 A=4e-12 P=8e-6
XM9_102 net063 vinp net31 well_2537 sg13_lv_pmos w=1u l=1u m=1
XT2538 net31 well_2538 ntap1 A=4e-12 P=8e-6
XM9_103 net063 vinp net31 well_2538 sg13_lv_pmos w=1u l=1u m=1
XT2539 net31 well_2539 ntap1 A=4e-12 P=8e-6
XM9_104 net063 vinp net31 well_2539 sg13_lv_pmos w=1u l=1u m=1
XT2540 net31 well_2540 ntap1 A=4e-12 P=8e-6
XM9_105 net063 vinp net31 well_2540 sg13_lv_pmos w=1u l=1u m=1
XT2541 net31 well_2541 ntap1 A=4e-12 P=8e-6
XM9_106 net063 vinp net31 well_2541 sg13_lv_pmos w=1u l=1u m=1
XT2542 net31 well_2542 ntap1 A=4e-12 P=8e-6
XM9_107 net063 vinp net31 well_2542 sg13_lv_pmos w=1u l=1u m=1
XT2543 net31 well_2543 ntap1 A=4e-12 P=8e-6
XM9_108 net063 vinp net31 well_2543 sg13_lv_pmos w=1u l=1u m=1
XT2544 net31 well_2544 ntap1 A=4e-12 P=8e-6
XM9_109 net063 vinp net31 well_2544 sg13_lv_pmos w=1u l=1u m=1
XT2545 net31 well_2545 ntap1 A=4e-12 P=8e-6
XM9_110 net063 vinp net31 well_2545 sg13_lv_pmos w=1u l=1u m=1
XT2546 net31 well_2546 ntap1 A=4e-12 P=8e-6
XM9_111 net063 vinp net31 well_2546 sg13_lv_pmos w=1u l=1u m=1
XT2547 net31 well_2547 ntap1 A=4e-12 P=8e-6
XM9_112 net063 vinp net31 well_2547 sg13_lv_pmos w=1u l=1u m=1
XT2548 net31 well_2548 ntap1 A=4e-12 P=8e-6
XM9_113 net063 vinp net31 well_2548 sg13_lv_pmos w=1u l=1u m=1
XT2549 net31 well_2549 ntap1 A=4e-12 P=8e-6
XM9_114 net063 vinp net31 well_2549 sg13_lv_pmos w=1u l=1u m=1
XT2550 net31 well_2550 ntap1 A=4e-12 P=8e-6
XM9_115 net063 vinp net31 well_2550 sg13_lv_pmos w=1u l=1u m=1
XT2551 net31 well_2551 ntap1 A=4e-12 P=8e-6
XM9_116 net063 vinp net31 well_2551 sg13_lv_pmos w=1u l=1u m=1
XT2552 net31 well_2552 ntap1 A=4e-12 P=8e-6
XM9_117 net063 vinp net31 well_2552 sg13_lv_pmos w=1u l=1u m=1
XT2553 net31 well_2553 ntap1 A=4e-12 P=8e-6
XM9_118 net063 vinp net31 well_2553 sg13_lv_pmos w=1u l=1u m=1
XT2554 net31 well_2554 ntap1 A=4e-12 P=8e-6
XM9_119 net063 vinp net31 well_2554 sg13_lv_pmos w=1u l=1u m=1
XT2555 net31 well_2555 ntap1 A=4e-12 P=8e-6
XM9_120 net063 vinp net31 well_2555 sg13_lv_pmos w=1u l=1u m=1
XT2556 net31 well_2556 ntap1 A=4e-12 P=8e-6
XM9_121 net063 vinp net31 well_2556 sg13_lv_pmos w=1u l=1u m=1
XT2557 net31 well_2557 ntap1 A=4e-12 P=8e-6
XM9_122 net063 vinp net31 well_2557 sg13_lv_pmos w=1u l=1u m=1
XT2558 net31 well_2558 ntap1 A=4e-12 P=8e-6
XM9_123 net063 vinp net31 well_2558 sg13_lv_pmos w=1u l=1u m=1
XT2559 net31 well_2559 ntap1 A=4e-12 P=8e-6
XM9_124 net063 vinp net31 well_2559 sg13_lv_pmos w=1u l=1u m=1
XT2560 net31 well_2560 ntap1 A=4e-12 P=8e-6
XM9_125 net063 vinp net31 well_2560 sg13_lv_pmos w=1u l=1u m=1
XT2561 net31 well_2561 ntap1 A=4e-12 P=8e-6
XM9_126 net063 vinp net31 well_2561 sg13_lv_pmos w=1u l=1u m=1
XT2562 net31 well_2562 ntap1 A=4e-12 P=8e-6
XM9_127 net063 vinp net31 well_2562 sg13_lv_pmos w=1u l=1u m=1
XT2563 net31 well_2563 ntap1 A=4e-12 P=8e-6
XM9_128 net063 vinp net31 well_2563 sg13_lv_pmos w=1u l=1u m=1
XT2564 net31 well_2564 ntap1 A=4e-12 P=8e-6
XM9_129 net063 vinp net31 well_2564 sg13_lv_pmos w=1u l=1u m=1
XT2565 net31 well_2565 ntap1 A=4e-12 P=8e-6
XM9_130 net063 vinp net31 well_2565 sg13_lv_pmos w=1u l=1u m=1
XT2566 net31 well_2566 ntap1 A=4e-12 P=8e-6
XM9_131 net063 vinp net31 well_2566 sg13_lv_pmos w=1u l=1u m=1
XT2567 net31 well_2567 ntap1 A=4e-12 P=8e-6
XM9_132 net063 vinp net31 well_2567 sg13_lv_pmos w=1u l=1u m=1
XT2568 net31 well_2568 ntap1 A=4e-12 P=8e-6
XM9_133 net063 vinp net31 well_2568 sg13_lv_pmos w=1u l=1u m=1
XT2569 net31 well_2569 ntap1 A=4e-12 P=8e-6
XM9_134 net063 vinp net31 well_2569 sg13_lv_pmos w=1u l=1u m=1
XT2570 net31 well_2570 ntap1 A=4e-12 P=8e-6
XM9_135 net063 vinp net31 well_2570 sg13_lv_pmos w=1u l=1u m=1
XT2571 net31 well_2571 ntap1 A=4e-12 P=8e-6
XM9_136 net063 vinp net31 well_2571 sg13_lv_pmos w=1u l=1u m=1
XT2572 net31 well_2572 ntap1 A=4e-12 P=8e-6
XM9_137 net063 vinp net31 well_2572 sg13_lv_pmos w=1u l=1u m=1
XT2573 net31 well_2573 ntap1 A=4e-12 P=8e-6
XM9_138 net063 vinp net31 well_2573 sg13_lv_pmos w=1u l=1u m=1
XT2574 net31 well_2574 ntap1 A=4e-12 P=8e-6
XM9_139 net063 vinp net31 well_2574 sg13_lv_pmos w=1u l=1u m=1
XT2575 net31 well_2575 ntap1 A=4e-12 P=8e-6
XM9_140 net063 vinp net31 well_2575 sg13_lv_pmos w=1u l=1u m=1
XT2576 net31 well_2576 ntap1 A=4e-12 P=8e-6
XM9_141 net063 vinp net31 well_2576 sg13_lv_pmos w=1u l=1u m=1
XT2577 net31 well_2577 ntap1 A=4e-12 P=8e-6
XM9_142 net063 vinp net31 well_2577 sg13_lv_pmos w=1u l=1u m=1
XT2578 net31 well_2578 ntap1 A=4e-12 P=8e-6
XM9_143 net063 vinp net31 well_2578 sg13_lv_pmos w=1u l=1u m=1
XT2579 net31 well_2579 ntap1 A=4e-12 P=8e-6
XM9_144 net063 vinp net31 well_2579 sg13_lv_pmos w=1u l=1u m=1
XT2580 net31 well_2580 ntap1 A=4e-12 P=8e-6
XM9_145 net063 vinp net31 well_2580 sg13_lv_pmos w=1u l=1u m=1
XT2581 net31 well_2581 ntap1 A=4e-12 P=8e-6
XM9_146 net063 vinp net31 well_2581 sg13_lv_pmos w=1u l=1u m=1
XT2582 net31 well_2582 ntap1 A=4e-12 P=8e-6
XM9_147 net063 vinp net31 well_2582 sg13_lv_pmos w=1u l=1u m=1
XTSUB vss sub ptap1 A=4e-12 P=8e-6
XC0_0 net050 vout cap_cmim w=51.18u l=51.18u m=1
XC0_1 net050 vout cap_cmim w=51.18u l=51.18u m=1
XC0_2 net050 vout cap_cmim w=51.18u l=51.18u m=1
XC0_3 net050 vout cap_cmim w=51.18u l=51.18u m=1
XC0_4 net050 vout cap_cmim w=51.18u l=51.18u m=1
XC0_5 net050 vout cap_cmim w=51.18u l=51.18u m=1
XC0_6 net050 vout cap_cmim w=51.18u l=51.18u m=1
XC0_7 net050 vout cap_cmim w=51.18u l=51.18u m=1
XC0_8 net050 vout cap_cmim w=51.18u l=51.18u m=1
XC0_9 net050 vout cap_cmim w=51.18u l=51.18u m=1
XC0_10 net050 vout cap_cmim w=51.18u l=51.18u m=1
XC0_11 net050 vout cap_cmim w=51.18u l=51.18u m=1
XC0_12 net050 vout cap_cmim w=51.18u l=51.18u m=1
XC0_13 net050 vout cap_cmim w=51.18u l=51.18u m=1
XC0_14 net050 vout cap_cmim w=51.18u l=51.18u m=1
XC0_15 net050 vout cap_cmim w=51.18u l=51.18u m=1
XC1_0 net050 net049 cap_cmim w=48.74u l=48.74u m=1
XC1_1 net050 net049 cap_cmim w=48.74u l=48.74u m=1
XC1_2 net050 net049 cap_cmim w=48.74u l=48.74u m=1
XC1_3 net050 net049 cap_cmim w=48.74u l=48.74u m=1
XC1_4 net050 net049 cap_cmim w=48.74u l=48.74u m=1
XC1_5 net050 net049 cap_cmim w=48.74u l=48.74u m=1
XC1_6 net050 net049 cap_cmim w=48.74u l=48.74u m=1
.ends amp_014_ramos_pfc
