* Copyright 2026 Danial Noori Zadeh. See collection LICENSE and NOTICE.
* Fixed IHP binding; external bias ports and native physical taps.
.subckt amp_014_ramos_pfc vss vdd vinn vinp vout net1
RT0 vdd well_0 ntap1 A=4e-12 P=8e-6
MM0_0 net1 net1 vdd well_0 sg13_lv_pmos w=1u l=1u m=1
RT1 vdd well_1 ntap1 A=4e-12 P=8e-6
MM0_1 net1 net1 vdd well_1 sg13_lv_pmos w=1u l=1u m=1
RT2 vdd well_2 ntap1 A=4e-12 P=8e-6
MM0_2 net1 net1 vdd well_2 sg13_lv_pmos w=1u l=1u m=1
RT3 vdd well_3 ntap1 A=4e-12 P=8e-6
MM0_3 net1 net1 vdd well_3 sg13_lv_pmos w=1u l=1u m=1
RT4 vdd well_4 ntap1 A=4e-12 P=8e-6
MM0_4 net1 net1 vdd well_4 sg13_lv_pmos w=1u l=1u m=1
RT5 vdd well_5 ntap1 A=4e-12 P=8e-6
MM0_5 net1 net1 vdd well_5 sg13_lv_pmos w=1u l=1u m=1
RT6 vdd well_6 ntap1 A=4e-12 P=8e-6
MM0_6 net1 net1 vdd well_6 sg13_lv_pmos w=1u l=1u m=1
RT7 vdd well_7 ntap1 A=4e-12 P=8e-6
MM0_7 net1 net1 vdd well_7 sg13_lv_pmos w=1u l=1u m=1
RT8 vdd well_8 ntap1 A=4e-12 P=8e-6
MM0_8 net1 net1 vdd well_8 sg13_lv_pmos w=1u l=1u m=1
RT9 vdd well_9 ntap1 A=4e-12 P=8e-6
MM0_9 net1 net1 vdd well_9 sg13_lv_pmos w=1u l=1u m=1
RT10 vdd well_10 ntap1 A=4e-12 P=8e-6
MM0_10 net1 net1 vdd well_10 sg13_lv_pmos w=1u l=1u m=1
RT11 vdd well_11 ntap1 A=4e-12 P=8e-6
MM0_11 net1 net1 vdd well_11 sg13_lv_pmos w=1u l=1u m=1
RT12 vdd well_12 ntap1 A=4e-12 P=8e-6
MM0_12 net1 net1 vdd well_12 sg13_lv_pmos w=1u l=1u m=1
RT13 vdd well_13 ntap1 A=4e-12 P=8e-6
MM0_13 net1 net1 vdd well_13 sg13_lv_pmos w=1u l=1u m=1
RT14 vdd well_14 ntap1 A=4e-12 P=8e-6
MM0_14 net1 net1 vdd well_14 sg13_lv_pmos w=1u l=1u m=1
RT15 vdd well_15 ntap1 A=4e-12 P=8e-6
MM0_15 net1 net1 vdd well_15 sg13_lv_pmos w=1u l=1u m=1
RT16 vdd well_16 ntap1 A=4e-12 P=8e-6
MM0_16 net1 net1 vdd well_16 sg13_lv_pmos w=1u l=1u m=1
RT17 vdd well_17 ntap1 A=4e-12 P=8e-6
MM0_17 net1 net1 vdd well_17 sg13_lv_pmos w=1u l=1u m=1
RT18 vdd well_18 ntap1 A=4e-12 P=8e-6
MM0_18 net1 net1 vdd well_18 sg13_lv_pmos w=1u l=1u m=1
RT19 vdd well_19 ntap1 A=4e-12 P=8e-6
MM0_19 net1 net1 vdd well_19 sg13_lv_pmos w=1u l=1u m=1
RT20 vdd well_20 ntap1 A=4e-12 P=8e-6
MM0_20 net1 net1 vdd well_20 sg13_lv_pmos w=1u l=1u m=1
RT21 vdd well_21 ntap1 A=4e-12 P=8e-6
MM0_21 net1 net1 vdd well_21 sg13_lv_pmos w=1u l=1u m=1
RT22 vdd well_22 ntap1 A=4e-12 P=8e-6
MM0_22 net1 net1 vdd well_22 sg13_lv_pmos w=1u l=1u m=1
RT23 vdd well_23 ntap1 A=4e-12 P=8e-6
MM0_23 net1 net1 vdd well_23 sg13_lv_pmos w=1u l=1u m=1
RT24 vdd well_24 ntap1 A=4e-12 P=8e-6
MM0_24 net1 net1 vdd well_24 sg13_lv_pmos w=1u l=1u m=1
RT25 vdd well_25 ntap1 A=4e-12 P=8e-6
MM0_25 net1 net1 vdd well_25 sg13_lv_pmos w=1u l=1u m=1
RT26 vdd well_26 ntap1 A=4e-12 P=8e-6
MM0_26 net1 net1 vdd well_26 sg13_lv_pmos w=1u l=1u m=1
RT27 vdd well_27 ntap1 A=4e-12 P=8e-6
MM0_27 net1 net1 vdd well_27 sg13_lv_pmos w=1u l=1u m=1
RT28 vdd well_28 ntap1 A=4e-12 P=8e-6
MM0_28 net1 net1 vdd well_28 sg13_lv_pmos w=1u l=1u m=1
RT29 vdd well_29 ntap1 A=4e-12 P=8e-6
MM0_29 net1 net1 vdd well_29 sg13_lv_pmos w=1u l=1u m=1
RT30 vdd well_30 ntap1 A=4e-12 P=8e-6
MM0_30 net1 net1 vdd well_30 sg13_lv_pmos w=1u l=1u m=1
RT31 vdd well_31 ntap1 A=4e-12 P=8e-6
MM0_31 net1 net1 vdd well_31 sg13_lv_pmos w=1u l=1u m=1
RT32 vdd well_32 ntap1 A=4e-12 P=8e-6
MM0_32 net1 net1 vdd well_32 sg13_lv_pmos w=1u l=1u m=1
RT33 vdd well_33 ntap1 A=4e-12 P=8e-6
MM0_33 net1 net1 vdd well_33 sg13_lv_pmos w=1u l=1u m=1
RT34 vdd well_34 ntap1 A=4e-12 P=8e-6
MM0_34 net1 net1 vdd well_34 sg13_lv_pmos w=1u l=1u m=1
RT35 vdd well_35 ntap1 A=4e-12 P=8e-6
MM0_35 net1 net1 vdd well_35 sg13_lv_pmos w=1u l=1u m=1
RT36 vdd well_36 ntap1 A=4e-12 P=8e-6
MM0_36 net1 net1 vdd well_36 sg13_lv_pmos w=1u l=1u m=1
RT37 vdd well_37 ntap1 A=4e-12 P=8e-6
MM0_37 net1 net1 vdd well_37 sg13_lv_pmos w=1u l=1u m=1
RT38 vdd well_38 ntap1 A=4e-12 P=8e-6
MM0_38 net1 net1 vdd well_38 sg13_lv_pmos w=1u l=1u m=1
RT39 vdd well_39 ntap1 A=4e-12 P=8e-6
MM0_39 net1 net1 vdd well_39 sg13_lv_pmos w=1u l=1u m=1
RT40 vdd well_40 ntap1 A=4e-12 P=8e-6
MM0_40 net1 net1 vdd well_40 sg13_lv_pmos w=1u l=1u m=1
RT41 vdd well_41 ntap1 A=4e-12 P=8e-6
MM0_41 net1 net1 vdd well_41 sg13_lv_pmos w=1u l=1u m=1
RT42 vdd well_42 ntap1 A=4e-12 P=8e-6
MM0_42 net1 net1 vdd well_42 sg13_lv_pmos w=1u l=1u m=1
RT43 vdd well_43 ntap1 A=4e-12 P=8e-6
MM0_43 net1 net1 vdd well_43 sg13_lv_pmos w=1u l=1u m=1
RT44 vdd well_44 ntap1 A=4e-12 P=8e-6
MM0_44 net1 net1 vdd well_44 sg13_lv_pmos w=1u l=1u m=1
RT45 vdd well_45 ntap1 A=4e-12 P=8e-6
MM0_45 net1 net1 vdd well_45 sg13_lv_pmos w=1u l=1u m=1
RT46 vdd well_46 ntap1 A=4e-12 P=8e-6
MM0_46 net1 net1 vdd well_46 sg13_lv_pmos w=1u l=1u m=1
RT47 vdd well_47 ntap1 A=4e-12 P=8e-6
MM0_47 net1 net1 vdd well_47 sg13_lv_pmos w=1u l=1u m=1
RT48 vdd well_48 ntap1 A=4e-12 P=8e-6
MM0_48 net1 net1 vdd well_48 sg13_lv_pmos w=1u l=1u m=1
RT49 vdd well_49 ntap1 A=4e-12 P=8e-6
MM0_49 net1 net1 vdd well_49 sg13_lv_pmos w=1u l=1u m=1
RT50 vdd well_50 ntap1 A=4e-12 P=8e-6
MM0_50 net1 net1 vdd well_50 sg13_lv_pmos w=1u l=1u m=1
RT51 vdd well_51 ntap1 A=4e-12 P=8e-6
MM0_51 net1 net1 vdd well_51 sg13_lv_pmos w=1u l=1u m=1
RT52 vdd well_52 ntap1 A=4e-12 P=8e-6
MM0_52 net1 net1 vdd well_52 sg13_lv_pmos w=1u l=1u m=1
RT53 vdd well_53 ntap1 A=4e-12 P=8e-6
MM0_53 net1 net1 vdd well_53 sg13_lv_pmos w=1u l=1u m=1
RT54 vdd well_54 ntap1 A=4e-12 P=8e-6
MM0_54 net1 net1 vdd well_54 sg13_lv_pmos w=1u l=1u m=1
RT55 vdd well_55 ntap1 A=4e-12 P=8e-6
MM0_55 net1 net1 vdd well_55 sg13_lv_pmos w=1u l=1u m=1
RT56 vdd well_56 ntap1 A=4e-12 P=8e-6
MM0_56 net1 net1 vdd well_56 sg13_lv_pmos w=1u l=1u m=1
RT57 vdd well_57 ntap1 A=4e-12 P=8e-6
MM0_57 net1 net1 vdd well_57 sg13_lv_pmos w=1u l=1u m=1
RT58 vdd well_58 ntap1 A=4e-12 P=8e-6
MM0_58 net1 net1 vdd well_58 sg13_lv_pmos w=1u l=1u m=1
RT59 vdd well_59 ntap1 A=4e-12 P=8e-6
MM0_59 net1 net1 vdd well_59 sg13_lv_pmos w=1u l=1u m=1
RT60 vdd well_60 ntap1 A=4e-12 P=8e-6
MM0_60 net1 net1 vdd well_60 sg13_lv_pmos w=1u l=1u m=1
RT61 vdd well_61 ntap1 A=4e-12 P=8e-6
MM0_61 net1 net1 vdd well_61 sg13_lv_pmos w=1u l=1u m=1
RT62 vdd well_62 ntap1 A=4e-12 P=8e-6
MM0_62 net1 net1 vdd well_62 sg13_lv_pmos w=1u l=1u m=1
RT63 vdd well_63 ntap1 A=4e-12 P=8e-6
MM0_63 net1 net1 vdd well_63 sg13_lv_pmos w=1u l=1u m=1
RT64 vdd well_64 ntap1 A=4e-12 P=8e-6
MM0_64 net1 net1 vdd well_64 sg13_lv_pmos w=1u l=1u m=1
RT65 vdd well_65 ntap1 A=4e-12 P=8e-6
MM0_65 net1 net1 vdd well_65 sg13_lv_pmos w=1u l=1u m=1
RT66 vdd well_66 ntap1 A=4e-12 P=8e-6
MM0_66 net1 net1 vdd well_66 sg13_lv_pmos w=1u l=1u m=1
RT67 vdd well_67 ntap1 A=4e-12 P=8e-6
MM0_67 net1 net1 vdd well_67 sg13_lv_pmos w=1u l=1u m=1
RT68 vdd well_68 ntap1 A=4e-12 P=8e-6
MM0_68 net1 net1 vdd well_68 sg13_lv_pmos w=1u l=1u m=1
RT69 vdd well_69 ntap1 A=4e-12 P=8e-6
MM0_69 net1 net1 vdd well_69 sg13_lv_pmos w=1u l=1u m=1
RT70 vdd well_70 ntap1 A=4e-12 P=8e-6
MM0_70 net1 net1 vdd well_70 sg13_lv_pmos w=1u l=1u m=1
RT71 vdd well_71 ntap1 A=4e-12 P=8e-6
MM1_0 vb4 net1 vdd well_71 sg13_lv_pmos w=1u l=1u m=1
RT72 vdd well_72 ntap1 A=4e-12 P=8e-6
MM1_1 vb4 net1 vdd well_72 sg13_lv_pmos w=1u l=1u m=1
RT73 vdd well_73 ntap1 A=4e-12 P=8e-6
MM1_2 vb4 net1 vdd well_73 sg13_lv_pmos w=1u l=1u m=1
RT74 vdd well_74 ntap1 A=4e-12 P=8e-6
MM1_3 vb4 net1 vdd well_74 sg13_lv_pmos w=1u l=1u m=1
RT75 vdd well_75 ntap1 A=4e-12 P=8e-6
MM1_4 vb4 net1 vdd well_75 sg13_lv_pmos w=1u l=1u m=1
RT76 vdd well_76 ntap1 A=4e-12 P=8e-6
MM1_5 vb4 net1 vdd well_76 sg13_lv_pmos w=1u l=1u m=1
RT77 vdd well_77 ntap1 A=4e-12 P=8e-6
MM1_6 vb4 net1 vdd well_77 sg13_lv_pmos w=1u l=1u m=1
RT78 vdd well_78 ntap1 A=4e-12 P=8e-6
MM1_7 vb4 net1 vdd well_78 sg13_lv_pmos w=1u l=1u m=1
RT79 vdd well_79 ntap1 A=4e-12 P=8e-6
MM1_8 vb4 net1 vdd well_79 sg13_lv_pmos w=1u l=1u m=1
RT80 vdd well_80 ntap1 A=4e-12 P=8e-6
MM1_9 vb4 net1 vdd well_80 sg13_lv_pmos w=1u l=1u m=1
RT81 vdd well_81 ntap1 A=4e-12 P=8e-6
MM1_10 vb4 net1 vdd well_81 sg13_lv_pmos w=1u l=1u m=1
RT82 vdd well_82 ntap1 A=4e-12 P=8e-6
MM1_11 vb4 net1 vdd well_82 sg13_lv_pmos w=1u l=1u m=1
RT83 vdd well_83 ntap1 A=4e-12 P=8e-6
MM1_12 vb4 net1 vdd well_83 sg13_lv_pmos w=1u l=1u m=1
RT84 vdd well_84 ntap1 A=4e-12 P=8e-6
MM1_13 vb4 net1 vdd well_84 sg13_lv_pmos w=1u l=1u m=1
RT85 vdd well_85 ntap1 A=4e-12 P=8e-6
MM1_14 vb4 net1 vdd well_85 sg13_lv_pmos w=1u l=1u m=1
RT86 vdd well_86 ntap1 A=4e-12 P=8e-6
MM1_15 vb4 net1 vdd well_86 sg13_lv_pmos w=1u l=1u m=1
RT87 vdd well_87 ntap1 A=4e-12 P=8e-6
MM1_16 vb4 net1 vdd well_87 sg13_lv_pmos w=1u l=1u m=1
RT88 vdd well_88 ntap1 A=4e-12 P=8e-6
MM1_17 vb4 net1 vdd well_88 sg13_lv_pmos w=1u l=1u m=1
RT89 vdd well_89 ntap1 A=4e-12 P=8e-6
MM1_18 vb4 net1 vdd well_89 sg13_lv_pmos w=1u l=1u m=1
RT90 vdd well_90 ntap1 A=4e-12 P=8e-6
MM1_19 vb4 net1 vdd well_90 sg13_lv_pmos w=1u l=1u m=1
RT91 vdd well_91 ntap1 A=4e-12 P=8e-6
MM1_20 vb4 net1 vdd well_91 sg13_lv_pmos w=1u l=1u m=1
RT92 vdd well_92 ntap1 A=4e-12 P=8e-6
MM1_21 vb4 net1 vdd well_92 sg13_lv_pmos w=1u l=1u m=1
RT93 vdd well_93 ntap1 A=4e-12 P=8e-6
MM1_22 vb4 net1 vdd well_93 sg13_lv_pmos w=1u l=1u m=1
RT94 vdd well_94 ntap1 A=4e-12 P=8e-6
MM1_23 vb4 net1 vdd well_94 sg13_lv_pmos w=1u l=1u m=1
RT95 vdd well_95 ntap1 A=4e-12 P=8e-6
MM1_24 vb4 net1 vdd well_95 sg13_lv_pmos w=1u l=1u m=1
RT96 vdd well_96 ntap1 A=4e-12 P=8e-6
MM1_25 vb4 net1 vdd well_96 sg13_lv_pmos w=1u l=1u m=1
RT97 vdd well_97 ntap1 A=4e-12 P=8e-6
MM1_26 vb4 net1 vdd well_97 sg13_lv_pmos w=1u l=1u m=1
RT98 vdd well_98 ntap1 A=4e-12 P=8e-6
MM1_27 vb4 net1 vdd well_98 sg13_lv_pmos w=1u l=1u m=1
RT99 vdd well_99 ntap1 A=4e-12 P=8e-6
MM1_28 vb4 net1 vdd well_99 sg13_lv_pmos w=1u l=1u m=1
RT100 vdd well_100 ntap1 A=4e-12 P=8e-6
MM1_29 vb4 net1 vdd well_100 sg13_lv_pmos w=1u l=1u m=1
RT101 vdd well_101 ntap1 A=4e-12 P=8e-6
MM1_30 vb4 net1 vdd well_101 sg13_lv_pmos w=1u l=1u m=1
RT102 vdd well_102 ntap1 A=4e-12 P=8e-6
MM1_31 vb4 net1 vdd well_102 sg13_lv_pmos w=1u l=1u m=1
RT103 vdd well_103 ntap1 A=4e-12 P=8e-6
MM1_32 vb4 net1 vdd well_103 sg13_lv_pmos w=1u l=1u m=1
RT104 vdd well_104 ntap1 A=4e-12 P=8e-6
MM1_33 vb4 net1 vdd well_104 sg13_lv_pmos w=1u l=1u m=1
RT105 vdd well_105 ntap1 A=4e-12 P=8e-6
MM1_34 vb4 net1 vdd well_105 sg13_lv_pmos w=1u l=1u m=1
RT106 vdd well_106 ntap1 A=4e-12 P=8e-6
MM1_35 vb4 net1 vdd well_106 sg13_lv_pmos w=1u l=1u m=1
RT107 vdd well_107 ntap1 A=4e-12 P=8e-6
MM1_36 vb4 net1 vdd well_107 sg13_lv_pmos w=1u l=1u m=1
RT108 vdd well_108 ntap1 A=4e-12 P=8e-6
MM1_37 vb4 net1 vdd well_108 sg13_lv_pmos w=1u l=1u m=1
RT109 vdd well_109 ntap1 A=4e-12 P=8e-6
MM1_38 vb4 net1 vdd well_109 sg13_lv_pmos w=1u l=1u m=1
RT110 vdd well_110 ntap1 A=4e-12 P=8e-6
MM1_39 vb4 net1 vdd well_110 sg13_lv_pmos w=1u l=1u m=1
RT111 vdd well_111 ntap1 A=4e-12 P=8e-6
MM1_40 vb4 net1 vdd well_111 sg13_lv_pmos w=1u l=1u m=1
RT112 vdd well_112 ntap1 A=4e-12 P=8e-6
MM1_41 vb4 net1 vdd well_112 sg13_lv_pmos w=1u l=1u m=1
RT113 vdd well_113 ntap1 A=4e-12 P=8e-6
MM1_42 vb4 net1 vdd well_113 sg13_lv_pmos w=1u l=1u m=1
RT114 vdd well_114 ntap1 A=4e-12 P=8e-6
MM1_43 vb4 net1 vdd well_114 sg13_lv_pmos w=1u l=1u m=1
RT115 vdd well_115 ntap1 A=4e-12 P=8e-6
MM1_44 vb4 net1 vdd well_115 sg13_lv_pmos w=1u l=1u m=1
RT116 vdd well_116 ntap1 A=4e-12 P=8e-6
MM1_45 vb4 net1 vdd well_116 sg13_lv_pmos w=1u l=1u m=1
RT117 vdd well_117 ntap1 A=4e-12 P=8e-6
MM1_46 vb4 net1 vdd well_117 sg13_lv_pmos w=1u l=1u m=1
RT118 vdd well_118 ntap1 A=4e-12 P=8e-6
MM1_47 vb4 net1 vdd well_118 sg13_lv_pmos w=1u l=1u m=1
RT119 vdd well_119 ntap1 A=4e-12 P=8e-6
MM1_48 vb4 net1 vdd well_119 sg13_lv_pmos w=1u l=1u m=1
RT120 vdd well_120 ntap1 A=4e-12 P=8e-6
MM1_49 vb4 net1 vdd well_120 sg13_lv_pmos w=1u l=1u m=1
RT121 vdd well_121 ntap1 A=4e-12 P=8e-6
MM1_50 vb4 net1 vdd well_121 sg13_lv_pmos w=1u l=1u m=1
RT122 vdd well_122 ntap1 A=4e-12 P=8e-6
MM1_51 vb4 net1 vdd well_122 sg13_lv_pmos w=1u l=1u m=1
RT123 vdd well_123 ntap1 A=4e-12 P=8e-6
MM1_52 vb4 net1 vdd well_123 sg13_lv_pmos w=1u l=1u m=1
RT124 vdd well_124 ntap1 A=4e-12 P=8e-6
MM1_53 vb4 net1 vdd well_124 sg13_lv_pmos w=1u l=1u m=1
RT125 vdd well_125 ntap1 A=4e-12 P=8e-6
MM1_54 vb4 net1 vdd well_125 sg13_lv_pmos w=1u l=1u m=1
RT126 vdd well_126 ntap1 A=4e-12 P=8e-6
MM1_55 vb4 net1 vdd well_126 sg13_lv_pmos w=1u l=1u m=1
RT127 vdd well_127 ntap1 A=4e-12 P=8e-6
MM1_56 vb4 net1 vdd well_127 sg13_lv_pmos w=1u l=1u m=1
RT128 vdd well_128 ntap1 A=4e-12 P=8e-6
MM1_57 vb4 net1 vdd well_128 sg13_lv_pmos w=1u l=1u m=1
RT129 vdd well_129 ntap1 A=4e-12 P=8e-6
MM1_58 vb4 net1 vdd well_129 sg13_lv_pmos w=1u l=1u m=1
RT130 vdd well_130 ntap1 A=4e-12 P=8e-6
MM1_59 vb4 net1 vdd well_130 sg13_lv_pmos w=1u l=1u m=1
RT131 vdd well_131 ntap1 A=4e-12 P=8e-6
MM1_60 vb4 net1 vdd well_131 sg13_lv_pmos w=1u l=1u m=1
RT132 vdd well_132 ntap1 A=4e-12 P=8e-6
MM1_61 vb4 net1 vdd well_132 sg13_lv_pmos w=1u l=1u m=1
RT133 vdd well_133 ntap1 A=4e-12 P=8e-6
MM1_62 vb4 net1 vdd well_133 sg13_lv_pmos w=1u l=1u m=1
RT134 vdd well_134 ntap1 A=4e-12 P=8e-6
MM1_63 vb4 net1 vdd well_134 sg13_lv_pmos w=1u l=1u m=1
RT135 vdd well_135 ntap1 A=4e-12 P=8e-6
MM1_64 vb4 net1 vdd well_135 sg13_lv_pmos w=1u l=1u m=1
RT136 vdd well_136 ntap1 A=4e-12 P=8e-6
MM1_65 vb4 net1 vdd well_136 sg13_lv_pmos w=1u l=1u m=1
RT137 vdd well_137 ntap1 A=4e-12 P=8e-6
MM1_66 vb4 net1 vdd well_137 sg13_lv_pmos w=1u l=1u m=1
RT138 vdd well_138 ntap1 A=4e-12 P=8e-6
MM1_67 vb4 net1 vdd well_138 sg13_lv_pmos w=1u l=1u m=1
RT139 vdd well_139 ntap1 A=4e-12 P=8e-6
MM1_68 vb4 net1 vdd well_139 sg13_lv_pmos w=1u l=1u m=1
RT140 vdd well_140 ntap1 A=4e-12 P=8e-6
MM1_69 vb4 net1 vdd well_140 sg13_lv_pmos w=1u l=1u m=1
RT141 vdd well_141 ntap1 A=4e-12 P=8e-6
MM1_70 vb4 net1 vdd well_141 sg13_lv_pmos w=1u l=1u m=1
RT142 vdd well_142 ntap1 A=4e-12 P=8e-6
MM10_0 net043 net050 vdd well_142 sg13_lv_pmos w=1u l=1u m=1
RT143 vdd well_143 ntap1 A=4e-12 P=8e-6
MM10_1 net043 net050 vdd well_143 sg13_lv_pmos w=1u l=1u m=1
RT144 vdd well_144 ntap1 A=4e-12 P=8e-6
MM10_2 net043 net050 vdd well_144 sg13_lv_pmos w=1u l=1u m=1
RT145 vdd well_145 ntap1 A=4e-12 P=8e-6
MM10_3 net043 net050 vdd well_145 sg13_lv_pmos w=1u l=1u m=1
RT146 vdd well_146 ntap1 A=4e-12 P=8e-6
MM10_4 net043 net050 vdd well_146 sg13_lv_pmos w=1u l=1u m=1
RT147 vdd well_147 ntap1 A=4e-12 P=8e-6
MM10_5 net043 net050 vdd well_147 sg13_lv_pmos w=1u l=1u m=1
RT148 vdd well_148 ntap1 A=4e-12 P=8e-6
MM10_6 net043 net050 vdd well_148 sg13_lv_pmos w=1u l=1u m=1
RT149 vdd well_149 ntap1 A=4e-12 P=8e-6
MM10_7 net043 net050 vdd well_149 sg13_lv_pmos w=1u l=1u m=1
RT150 vdd well_150 ntap1 A=4e-12 P=8e-6
MM10_8 net043 net050 vdd well_150 sg13_lv_pmos w=1u l=1u m=1
RT151 vdd well_151 ntap1 A=4e-12 P=8e-6
MM10_9 net043 net050 vdd well_151 sg13_lv_pmos w=1u l=1u m=1
RT152 vdd well_152 ntap1 A=4e-12 P=8e-6
MM10_10 net043 net050 vdd well_152 sg13_lv_pmos w=1u l=1u m=1
RT153 vdd well_153 ntap1 A=4e-12 P=8e-6
MM10_11 net043 net050 vdd well_153 sg13_lv_pmos w=1u l=1u m=1
RT154 vdd well_154 ntap1 A=4e-12 P=8e-6
MM10_12 net043 net050 vdd well_154 sg13_lv_pmos w=1u l=1u m=1
RT155 vdd well_155 ntap1 A=4e-12 P=8e-6
MM10_13 net043 net050 vdd well_155 sg13_lv_pmos w=1u l=1u m=1
RT156 vdd well_156 ntap1 A=4e-12 P=8e-6
MM10_14 net043 net050 vdd well_156 sg13_lv_pmos w=1u l=1u m=1
RT157 vdd well_157 ntap1 A=4e-12 P=8e-6
MM10_15 net043 net050 vdd well_157 sg13_lv_pmos w=1u l=1u m=1
RT158 vdd well_158 ntap1 A=4e-12 P=8e-6
MM10_16 net043 net050 vdd well_158 sg13_lv_pmos w=1u l=1u m=1
RT159 vdd well_159 ntap1 A=4e-12 P=8e-6
MM10_17 net043 net050 vdd well_159 sg13_lv_pmos w=1u l=1u m=1
RT160 vdd well_160 ntap1 A=4e-12 P=8e-6
MM10_18 net043 net050 vdd well_160 sg13_lv_pmos w=1u l=1u m=1
RT161 vdd well_161 ntap1 A=4e-12 P=8e-6
MM10_19 net043 net050 vdd well_161 sg13_lv_pmos w=1u l=1u m=1
RT162 vdd well_162 ntap1 A=4e-12 P=8e-6
MM10_20 net043 net050 vdd well_162 sg13_lv_pmos w=1u l=1u m=1
RT163 vdd well_163 ntap1 A=4e-12 P=8e-6
MM10_21 net043 net050 vdd well_163 sg13_lv_pmos w=1u l=1u m=1
RT164 vdd well_164 ntap1 A=4e-12 P=8e-6
MM10_22 net043 net050 vdd well_164 sg13_lv_pmos w=1u l=1u m=1
RT165 vdd well_165 ntap1 A=4e-12 P=8e-6
MM10_23 net043 net050 vdd well_165 sg13_lv_pmos w=1u l=1u m=1
RT166 vdd well_166 ntap1 A=4e-12 P=8e-6
MM10_24 net043 net050 vdd well_166 sg13_lv_pmos w=1u l=1u m=1
RT167 vdd well_167 ntap1 A=4e-12 P=8e-6
MM10_25 net043 net050 vdd well_167 sg13_lv_pmos w=1u l=1u m=1
RT168 vdd well_168 ntap1 A=4e-12 P=8e-6
MM10_26 net043 net050 vdd well_168 sg13_lv_pmos w=1u l=1u m=1
RT169 vdd well_169 ntap1 A=4e-12 P=8e-6
MM10_27 net043 net050 vdd well_169 sg13_lv_pmos w=1u l=1u m=1
RT170 vdd well_170 ntap1 A=4e-12 P=8e-6
MM10_28 net043 net050 vdd well_170 sg13_lv_pmos w=1u l=1u m=1
RT171 vdd well_171 ntap1 A=4e-12 P=8e-6
MM10_29 net043 net050 vdd well_171 sg13_lv_pmos w=1u l=1u m=1
RT172 vdd well_172 ntap1 A=4e-12 P=8e-6
MM10_30 net043 net050 vdd well_172 sg13_lv_pmos w=1u l=1u m=1
RT173 vdd well_173 ntap1 A=4e-12 P=8e-6
MM10_31 net043 net050 vdd well_173 sg13_lv_pmos w=1u l=1u m=1
RT174 vdd well_174 ntap1 A=4e-12 P=8e-6
MM10_32 net043 net050 vdd well_174 sg13_lv_pmos w=1u l=1u m=1
RT175 vdd well_175 ntap1 A=4e-12 P=8e-6
MM10_33 net043 net050 vdd well_175 sg13_lv_pmos w=1u l=1u m=1
RT176 vdd well_176 ntap1 A=4e-12 P=8e-6
MM10_34 net043 net050 vdd well_176 sg13_lv_pmos w=1u l=1u m=1
RT177 vdd well_177 ntap1 A=4e-12 P=8e-6
MM10_35 net043 net050 vdd well_177 sg13_lv_pmos w=1u l=1u m=1
RT178 vdd well_178 ntap1 A=4e-12 P=8e-6
MM10_36 net043 net050 vdd well_178 sg13_lv_pmos w=1u l=1u m=1
RT179 vdd well_179 ntap1 A=4e-12 P=8e-6
MM10_37 net043 net050 vdd well_179 sg13_lv_pmos w=1u l=1u m=1
RT180 vdd well_180 ntap1 A=4e-12 P=8e-6
MM10_38 net043 net050 vdd well_180 sg13_lv_pmos w=1u l=1u m=1
RT181 vdd well_181 ntap1 A=4e-12 P=8e-6
MM10_39 net043 net050 vdd well_181 sg13_lv_pmos w=1u l=1u m=1
RT182 vdd well_182 ntap1 A=4e-12 P=8e-6
MM10_40 net043 net050 vdd well_182 sg13_lv_pmos w=1u l=1u m=1
RT183 vdd well_183 ntap1 A=4e-12 P=8e-6
MM10_41 net043 net050 vdd well_183 sg13_lv_pmos w=1u l=1u m=1
RT184 vdd well_184 ntap1 A=4e-12 P=8e-6
MM10_42 net043 net050 vdd well_184 sg13_lv_pmos w=1u l=1u m=1
RT185 vdd well_185 ntap1 A=4e-12 P=8e-6
MM10_43 net043 net050 vdd well_185 sg13_lv_pmos w=1u l=1u m=1
RT186 vdd well_186 ntap1 A=4e-12 P=8e-6
MM10_44 net043 net050 vdd well_186 sg13_lv_pmos w=1u l=1u m=1
RT187 vdd well_187 ntap1 A=4e-12 P=8e-6
MM10_45 net043 net050 vdd well_187 sg13_lv_pmos w=1u l=1u m=1
RT188 vdd well_188 ntap1 A=4e-12 P=8e-6
MM10_46 net043 net050 vdd well_188 sg13_lv_pmos w=1u l=1u m=1
RT189 vdd well_189 ntap1 A=4e-12 P=8e-6
MM10_47 net043 net050 vdd well_189 sg13_lv_pmos w=1u l=1u m=1
RT190 vdd well_190 ntap1 A=4e-12 P=8e-6
MM10_48 net043 net050 vdd well_190 sg13_lv_pmos w=1u l=1u m=1
RT191 vdd well_191 ntap1 A=4e-12 P=8e-6
MM10_49 net043 net050 vdd well_191 sg13_lv_pmos w=1u l=1u m=1
RT192 vdd well_192 ntap1 A=4e-12 P=8e-6
MM10_50 net043 net050 vdd well_192 sg13_lv_pmos w=1u l=1u m=1
RT193 vdd well_193 ntap1 A=4e-12 P=8e-6
MM10_51 net043 net050 vdd well_193 sg13_lv_pmos w=1u l=1u m=1
RT194 vdd well_194 ntap1 A=4e-12 P=8e-6
MM10_52 net043 net050 vdd well_194 sg13_lv_pmos w=1u l=1u m=1
RT195 vdd well_195 ntap1 A=4e-12 P=8e-6
MM10_53 net043 net050 vdd well_195 sg13_lv_pmos w=1u l=1u m=1
RT196 vdd well_196 ntap1 A=4e-12 P=8e-6
MM10_54 net043 net050 vdd well_196 sg13_lv_pmos w=1u l=1u m=1
RT197 vdd well_197 ntap1 A=4e-12 P=8e-6
MM10_55 net043 net050 vdd well_197 sg13_lv_pmos w=1u l=1u m=1
RT198 vdd well_198 ntap1 A=4e-12 P=8e-6
MM10_56 net043 net050 vdd well_198 sg13_lv_pmos w=1u l=1u m=1
RT199 vdd well_199 ntap1 A=4e-12 P=8e-6
MM10_57 net043 net050 vdd well_199 sg13_lv_pmos w=1u l=1u m=1
RT200 vdd well_200 ntap1 A=4e-12 P=8e-6
MM10_58 net043 net050 vdd well_200 sg13_lv_pmos w=1u l=1u m=1
RT201 vdd well_201 ntap1 A=4e-12 P=8e-6
MM10_59 net043 net050 vdd well_201 sg13_lv_pmos w=1u l=1u m=1
RT202 vdd well_202 ntap1 A=4e-12 P=8e-6
MM10_60 net043 net050 vdd well_202 sg13_lv_pmos w=1u l=1u m=1
RT203 vdd well_203 ntap1 A=4e-12 P=8e-6
MM10_61 net043 net050 vdd well_203 sg13_lv_pmos w=1u l=1u m=1
RT204 vdd well_204 ntap1 A=4e-12 P=8e-6
MM10_62 net043 net050 vdd well_204 sg13_lv_pmos w=1u l=1u m=1
RT205 vdd well_205 ntap1 A=4e-12 P=8e-6
MM10_63 net043 net050 vdd well_205 sg13_lv_pmos w=1u l=1u m=1
RT206 vdd well_206 ntap1 A=4e-12 P=8e-6
MM10_64 net043 net050 vdd well_206 sg13_lv_pmos w=1u l=1u m=1
RT207 vdd well_207 ntap1 A=4e-12 P=8e-6
MM10_65 net043 net050 vdd well_207 sg13_lv_pmos w=1u l=1u m=1
RT208 vdd well_208 ntap1 A=4e-12 P=8e-6
MM10_66 net043 net050 vdd well_208 sg13_lv_pmos w=1u l=1u m=1
RT209 vdd well_209 ntap1 A=4e-12 P=8e-6
MM10_67 net043 net050 vdd well_209 sg13_lv_pmos w=1u l=1u m=1
RT210 vdd well_210 ntap1 A=4e-12 P=8e-6
MM10_68 net043 net050 vdd well_210 sg13_lv_pmos w=1u l=1u m=1
RT211 vdd well_211 ntap1 A=4e-12 P=8e-6
MM10_69 net043 net050 vdd well_211 sg13_lv_pmos w=1u l=1u m=1
RT212 vdd well_212 ntap1 A=4e-12 P=8e-6
MM10_70 net043 net050 vdd well_212 sg13_lv_pmos w=1u l=1u m=1
RT213 vdd well_213 ntap1 A=4e-12 P=8e-6
MM10_71 net043 net050 vdd well_213 sg13_lv_pmos w=1u l=1u m=1
RT214 vdd well_214 ntap1 A=4e-12 P=8e-6
MM10_72 net043 net050 vdd well_214 sg13_lv_pmos w=1u l=1u m=1
RT215 vdd well_215 ntap1 A=4e-12 P=8e-6
MM10_73 net043 net050 vdd well_215 sg13_lv_pmos w=1u l=1u m=1
RT216 vdd well_216 ntap1 A=4e-12 P=8e-6
MM10_74 net043 net050 vdd well_216 sg13_lv_pmos w=1u l=1u m=1
RT217 vdd well_217 ntap1 A=4e-12 P=8e-6
MM10_75 net043 net050 vdd well_217 sg13_lv_pmos w=1u l=1u m=1
RT218 vdd well_218 ntap1 A=4e-12 P=8e-6
MM10_76 net043 net050 vdd well_218 sg13_lv_pmos w=1u l=1u m=1
RT219 vdd well_219 ntap1 A=4e-12 P=8e-6
MM10_77 net043 net050 vdd well_219 sg13_lv_pmos w=1u l=1u m=1
RT220 vdd well_220 ntap1 A=4e-12 P=8e-6
MM10_78 net043 net050 vdd well_220 sg13_lv_pmos w=1u l=1u m=1
RT221 vdd well_221 ntap1 A=4e-12 P=8e-6
MM10_79 net043 net050 vdd well_221 sg13_lv_pmos w=1u l=1u m=1
RT222 vdd well_222 ntap1 A=4e-12 P=8e-6
MM10_80 net043 net050 vdd well_222 sg13_lv_pmos w=1u l=1u m=1
RT223 vdd well_223 ntap1 A=4e-12 P=8e-6
MM11_0 vout net050 vdd well_223 sg13_lv_pmos w=1u l=1u m=1
RT224 vdd well_224 ntap1 A=4e-12 P=8e-6
MM11_1 vout net050 vdd well_224 sg13_lv_pmos w=1u l=1u m=1
RT225 vdd well_225 ntap1 A=4e-12 P=8e-6
MM11_2 vout net050 vdd well_225 sg13_lv_pmos w=1u l=1u m=1
RT226 vdd well_226 ntap1 A=4e-12 P=8e-6
MM11_3 vout net050 vdd well_226 sg13_lv_pmos w=1u l=1u m=1
RT227 vdd well_227 ntap1 A=4e-12 P=8e-6
MM11_4 vout net050 vdd well_227 sg13_lv_pmos w=1u l=1u m=1
RT228 vdd well_228 ntap1 A=4e-12 P=8e-6
MM11_5 vout net050 vdd well_228 sg13_lv_pmos w=1u l=1u m=1
RT229 vdd well_229 ntap1 A=4e-12 P=8e-6
MM11_6 vout net050 vdd well_229 sg13_lv_pmos w=1u l=1u m=1
RT230 vdd well_230 ntap1 A=4e-12 P=8e-6
MM11_7 vout net050 vdd well_230 sg13_lv_pmos w=1u l=1u m=1
RT231 vdd well_231 ntap1 A=4e-12 P=8e-6
MM11_8 vout net050 vdd well_231 sg13_lv_pmos w=1u l=1u m=1
RT232 vdd well_232 ntap1 A=4e-12 P=8e-6
MM11_9 vout net050 vdd well_232 sg13_lv_pmos w=1u l=1u m=1
RT233 vdd well_233 ntap1 A=4e-12 P=8e-6
MM11_10 vout net050 vdd well_233 sg13_lv_pmos w=1u l=1u m=1
RT234 vdd well_234 ntap1 A=4e-12 P=8e-6
MM11_11 vout net050 vdd well_234 sg13_lv_pmos w=1u l=1u m=1
RT235 vdd well_235 ntap1 A=4e-12 P=8e-6
MM11_12 vout net050 vdd well_235 sg13_lv_pmos w=1u l=1u m=1
RT236 vdd well_236 ntap1 A=4e-12 P=8e-6
MM11_13 vout net050 vdd well_236 sg13_lv_pmos w=1u l=1u m=1
RT237 vdd well_237 ntap1 A=4e-12 P=8e-6
MM11_14 vout net050 vdd well_237 sg13_lv_pmos w=1u l=1u m=1
RT238 vdd well_238 ntap1 A=4e-12 P=8e-6
MM11_15 vout net050 vdd well_238 sg13_lv_pmos w=1u l=1u m=1
RT239 vdd well_239 ntap1 A=4e-12 P=8e-6
MM11_16 vout net050 vdd well_239 sg13_lv_pmos w=1u l=1u m=1
RT240 vdd well_240 ntap1 A=4e-12 P=8e-6
MM11_17 vout net050 vdd well_240 sg13_lv_pmos w=1u l=1u m=1
RT241 vdd well_241 ntap1 A=4e-12 P=8e-6
MM11_18 vout net050 vdd well_241 sg13_lv_pmos w=1u l=1u m=1
RT242 vdd well_242 ntap1 A=4e-12 P=8e-6
MM11_19 vout net050 vdd well_242 sg13_lv_pmos w=1u l=1u m=1
RT243 vdd well_243 ntap1 A=4e-12 P=8e-6
MM11_20 vout net050 vdd well_243 sg13_lv_pmos w=1u l=1u m=1
RT244 vdd well_244 ntap1 A=4e-12 P=8e-6
MM11_21 vout net050 vdd well_244 sg13_lv_pmos w=1u l=1u m=1
RT245 vdd well_245 ntap1 A=4e-12 P=8e-6
MM11_22 vout net050 vdd well_245 sg13_lv_pmos w=1u l=1u m=1
RT246 vdd well_246 ntap1 A=4e-12 P=8e-6
MM11_23 vout net050 vdd well_246 sg13_lv_pmos w=1u l=1u m=1
RT247 vdd well_247 ntap1 A=4e-12 P=8e-6
MM11_24 vout net050 vdd well_247 sg13_lv_pmos w=1u l=1u m=1
RT248 vdd well_248 ntap1 A=4e-12 P=8e-6
MM11_25 vout net050 vdd well_248 sg13_lv_pmos w=1u l=1u m=1
RT249 vdd well_249 ntap1 A=4e-12 P=8e-6
MM11_26 vout net050 vdd well_249 sg13_lv_pmos w=1u l=1u m=1
RT250 vdd well_250 ntap1 A=4e-12 P=8e-6
MM11_27 vout net050 vdd well_250 sg13_lv_pmos w=1u l=1u m=1
RT251 vdd well_251 ntap1 A=4e-12 P=8e-6
MM11_28 vout net050 vdd well_251 sg13_lv_pmos w=1u l=1u m=1
RT252 vdd well_252 ntap1 A=4e-12 P=8e-6
MM11_29 vout net050 vdd well_252 sg13_lv_pmos w=1u l=1u m=1
RT253 vdd well_253 ntap1 A=4e-12 P=8e-6
MM11_30 vout net050 vdd well_253 sg13_lv_pmos w=1u l=1u m=1
RT254 vdd well_254 ntap1 A=4e-12 P=8e-6
MM11_31 vout net050 vdd well_254 sg13_lv_pmos w=1u l=1u m=1
RT255 vdd well_255 ntap1 A=4e-12 P=8e-6
MM11_32 vout net050 vdd well_255 sg13_lv_pmos w=1u l=1u m=1
RT256 vdd well_256 ntap1 A=4e-12 P=8e-6
MM11_33 vout net050 vdd well_256 sg13_lv_pmos w=1u l=1u m=1
RT257 vdd well_257 ntap1 A=4e-12 P=8e-6
MM11_34 vout net050 vdd well_257 sg13_lv_pmos w=1u l=1u m=1
RT258 vdd well_258 ntap1 A=4e-12 P=8e-6
MM11_35 vout net050 vdd well_258 sg13_lv_pmos w=1u l=1u m=1
RT259 vdd well_259 ntap1 A=4e-12 P=8e-6
MM11_36 vout net050 vdd well_259 sg13_lv_pmos w=1u l=1u m=1
RT260 vdd well_260 ntap1 A=4e-12 P=8e-6
MM11_37 vout net050 vdd well_260 sg13_lv_pmos w=1u l=1u m=1
RT261 vdd well_261 ntap1 A=4e-12 P=8e-6
MM11_38 vout net050 vdd well_261 sg13_lv_pmos w=1u l=1u m=1
RT262 vdd well_262 ntap1 A=4e-12 P=8e-6
MM11_39 vout net050 vdd well_262 sg13_lv_pmos w=1u l=1u m=1
RT263 vdd well_263 ntap1 A=4e-12 P=8e-6
MM11_40 vout net050 vdd well_263 sg13_lv_pmos w=1u l=1u m=1
RT264 vdd well_264 ntap1 A=4e-12 P=8e-6
MM11_41 vout net050 vdd well_264 sg13_lv_pmos w=1u l=1u m=1
RT265 vdd well_265 ntap1 A=4e-12 P=8e-6
MM11_42 vout net050 vdd well_265 sg13_lv_pmos w=1u l=1u m=1
RT266 vdd well_266 ntap1 A=4e-12 P=8e-6
MM11_43 vout net050 vdd well_266 sg13_lv_pmos w=1u l=1u m=1
RT267 vdd well_267 ntap1 A=4e-12 P=8e-6
MM11_44 vout net050 vdd well_267 sg13_lv_pmos w=1u l=1u m=1
RT268 vdd well_268 ntap1 A=4e-12 P=8e-6
MM11_45 vout net050 vdd well_268 sg13_lv_pmos w=1u l=1u m=1
RT269 vdd well_269 ntap1 A=4e-12 P=8e-6
MM11_46 vout net050 vdd well_269 sg13_lv_pmos w=1u l=1u m=1
RT270 vdd well_270 ntap1 A=4e-12 P=8e-6
MM11_47 vout net050 vdd well_270 sg13_lv_pmos w=1u l=1u m=1
RT271 vdd well_271 ntap1 A=4e-12 P=8e-6
MM11_48 vout net050 vdd well_271 sg13_lv_pmos w=1u l=1u m=1
RT272 vdd well_272 ntap1 A=4e-12 P=8e-6
MM11_49 vout net050 vdd well_272 sg13_lv_pmos w=1u l=1u m=1
RT273 vdd well_273 ntap1 A=4e-12 P=8e-6
MM11_50 vout net050 vdd well_273 sg13_lv_pmos w=1u l=1u m=1
RT274 vdd well_274 ntap1 A=4e-12 P=8e-6
MM11_51 vout net050 vdd well_274 sg13_lv_pmos w=1u l=1u m=1
RT275 vdd well_275 ntap1 A=4e-12 P=8e-6
MM11_52 vout net050 vdd well_275 sg13_lv_pmos w=1u l=1u m=1
RT276 vdd well_276 ntap1 A=4e-12 P=8e-6
MM11_53 vout net050 vdd well_276 sg13_lv_pmos w=1u l=1u m=1
RT277 vdd well_277 ntap1 A=4e-12 P=8e-6
MM11_54 vout net050 vdd well_277 sg13_lv_pmos w=1u l=1u m=1
RT278 vdd well_278 ntap1 A=4e-12 P=8e-6
MM11_55 vout net050 vdd well_278 sg13_lv_pmos w=1u l=1u m=1
RT279 vdd well_279 ntap1 A=4e-12 P=8e-6
MM11_56 vout net050 vdd well_279 sg13_lv_pmos w=1u l=1u m=1
RT280 vdd well_280 ntap1 A=4e-12 P=8e-6
MM11_57 vout net050 vdd well_280 sg13_lv_pmos w=1u l=1u m=1
RT281 vdd well_281 ntap1 A=4e-12 P=8e-6
MM11_58 vout net050 vdd well_281 sg13_lv_pmos w=1u l=1u m=1
RT282 vdd well_282 ntap1 A=4e-12 P=8e-6
MM11_59 vout net050 vdd well_282 sg13_lv_pmos w=1u l=1u m=1
RT283 vdd well_283 ntap1 A=4e-12 P=8e-6
MM11_60 vout net050 vdd well_283 sg13_lv_pmos w=1u l=1u m=1
RT284 vdd well_284 ntap1 A=4e-12 P=8e-6
MM11_61 vout net050 vdd well_284 sg13_lv_pmos w=1u l=1u m=1
RT285 vdd well_285 ntap1 A=4e-12 P=8e-6
MM11_62 vout net050 vdd well_285 sg13_lv_pmos w=1u l=1u m=1
RT286 vdd well_286 ntap1 A=4e-12 P=8e-6
MM11_63 vout net050 vdd well_286 sg13_lv_pmos w=1u l=1u m=1
RT287 vdd well_287 ntap1 A=4e-12 P=8e-6
MM11_64 vout net050 vdd well_287 sg13_lv_pmos w=1u l=1u m=1
RT288 vdd well_288 ntap1 A=4e-12 P=8e-6
MM11_65 vout net050 vdd well_288 sg13_lv_pmos w=1u l=1u m=1
RT289 vdd well_289 ntap1 A=4e-12 P=8e-6
MM11_66 vout net050 vdd well_289 sg13_lv_pmos w=1u l=1u m=1
RT290 vdd well_290 ntap1 A=4e-12 P=8e-6
MM11_67 vout net050 vdd well_290 sg13_lv_pmos w=1u l=1u m=1
RT291 vdd well_291 ntap1 A=4e-12 P=8e-6
MM11_68 vout net050 vdd well_291 sg13_lv_pmos w=1u l=1u m=1
RT292 vdd well_292 ntap1 A=4e-12 P=8e-6
MM11_69 vout net050 vdd well_292 sg13_lv_pmos w=1u l=1u m=1
RT293 vdd well_293 ntap1 A=4e-12 P=8e-6
MM11_70 vout net050 vdd well_293 sg13_lv_pmos w=1u l=1u m=1
RT294 vdd well_294 ntap1 A=4e-12 P=8e-6
MM11_71 vout net050 vdd well_294 sg13_lv_pmos w=1u l=1u m=1
RT295 vdd well_295 ntap1 A=4e-12 P=8e-6
MM11_72 vout net050 vdd well_295 sg13_lv_pmos w=1u l=1u m=1
RT296 vdd well_296 ntap1 A=4e-12 P=8e-6
MM11_73 vout net050 vdd well_296 sg13_lv_pmos w=1u l=1u m=1
RT297 vdd well_297 ntap1 A=4e-12 P=8e-6
MM11_74 vout net050 vdd well_297 sg13_lv_pmos w=1u l=1u m=1
RT298 vdd well_298 ntap1 A=4e-12 P=8e-6
MM11_75 vout net050 vdd well_298 sg13_lv_pmos w=1u l=1u m=1
RT299 vdd well_299 ntap1 A=4e-12 P=8e-6
MM11_76 vout net050 vdd well_299 sg13_lv_pmos w=1u l=1u m=1
RT300 vdd well_300 ntap1 A=4e-12 P=8e-6
MM11_77 vout net050 vdd well_300 sg13_lv_pmos w=1u l=1u m=1
RT301 vdd well_301 ntap1 A=4e-12 P=8e-6
MM11_78 vout net050 vdd well_301 sg13_lv_pmos w=1u l=1u m=1
RT302 vdd well_302 ntap1 A=4e-12 P=8e-6
MM11_79 vout net050 vdd well_302 sg13_lv_pmos w=1u l=1u m=1
RT303 vdd well_303 ntap1 A=4e-12 P=8e-6
MM11_80 vout net050 vdd well_303 sg13_lv_pmos w=1u l=1u m=1
RT304 vdd well_304 ntap1 A=4e-12 P=8e-6
MM11_81 vout net050 vdd well_304 sg13_lv_pmos w=1u l=1u m=1
RT305 vdd well_305 ntap1 A=4e-12 P=8e-6
MM11_82 vout net050 vdd well_305 sg13_lv_pmos w=1u l=1u m=1
RT306 vdd well_306 ntap1 A=4e-12 P=8e-6
MM11_83 vout net050 vdd well_306 sg13_lv_pmos w=1u l=1u m=1
RT307 vdd well_307 ntap1 A=4e-12 P=8e-6
MM11_84 vout net050 vdd well_307 sg13_lv_pmos w=1u l=1u m=1
RT308 vdd well_308 ntap1 A=4e-12 P=8e-6
MM11_85 vout net050 vdd well_308 sg13_lv_pmos w=1u l=1u m=1
RT309 vdd well_309 ntap1 A=4e-12 P=8e-6
MM11_86 vout net050 vdd well_309 sg13_lv_pmos w=1u l=1u m=1
RT310 vdd well_310 ntap1 A=4e-12 P=8e-6
MM11_87 vout net050 vdd well_310 sg13_lv_pmos w=1u l=1u m=1
RT311 vdd well_311 ntap1 A=4e-12 P=8e-6
MM11_88 vout net050 vdd well_311 sg13_lv_pmos w=1u l=1u m=1
RT312 vdd well_312 ntap1 A=4e-12 P=8e-6
MM11_89 vout net050 vdd well_312 sg13_lv_pmos w=1u l=1u m=1
RT313 vdd well_313 ntap1 A=4e-12 P=8e-6
MM11_90 vout net050 vdd well_313 sg13_lv_pmos w=1u l=1u m=1
RT314 vdd well_314 ntap1 A=4e-12 P=8e-6
MM11_91 vout net050 vdd well_314 sg13_lv_pmos w=1u l=1u m=1
RT315 vdd well_315 ntap1 A=4e-12 P=8e-6
MM11_92 vout net050 vdd well_315 sg13_lv_pmos w=1u l=1u m=1
RT316 vdd well_316 ntap1 A=4e-12 P=8e-6
MM11_93 vout net050 vdd well_316 sg13_lv_pmos w=1u l=1u m=1
RT317 vdd well_317 ntap1 A=4e-12 P=8e-6
MM11_94 vout net050 vdd well_317 sg13_lv_pmos w=1u l=1u m=1
RT318 vdd well_318 ntap1 A=4e-12 P=8e-6
MM11_95 vout net050 vdd well_318 sg13_lv_pmos w=1u l=1u m=1
RT319 vdd well_319 ntap1 A=4e-12 P=8e-6
MM11_96 vout net050 vdd well_319 sg13_lv_pmos w=1u l=1u m=1
RT320 vdd well_320 ntap1 A=4e-12 P=8e-6
MM11_97 vout net050 vdd well_320 sg13_lv_pmos w=1u l=1u m=1
RT321 vdd well_321 ntap1 A=4e-12 P=8e-6
MM11_98 vout net050 vdd well_321 sg13_lv_pmos w=1u l=1u m=1
RT322 vdd well_322 ntap1 A=4e-12 P=8e-6
MM11_99 vout net050 vdd well_322 sg13_lv_pmos w=1u l=1u m=1
RT323 vdd well_323 ntap1 A=4e-12 P=8e-6
MM11_100 vout net050 vdd well_323 sg13_lv_pmos w=1u l=1u m=1
RT324 vdd well_324 ntap1 A=4e-12 P=8e-6
MM11_101 vout net050 vdd well_324 sg13_lv_pmos w=1u l=1u m=1
RT325 vdd well_325 ntap1 A=4e-12 P=8e-6
MM11_102 vout net050 vdd well_325 sg13_lv_pmos w=1u l=1u m=1
RT326 vdd well_326 ntap1 A=4e-12 P=8e-6
MM11_103 vout net050 vdd well_326 sg13_lv_pmos w=1u l=1u m=1
RT327 vdd well_327 ntap1 A=4e-12 P=8e-6
MM11_104 vout net050 vdd well_327 sg13_lv_pmos w=1u l=1u m=1
RT328 vdd well_328 ntap1 A=4e-12 P=8e-6
MM11_105 vout net050 vdd well_328 sg13_lv_pmos w=1u l=1u m=1
RT329 vdd well_329 ntap1 A=4e-12 P=8e-6
MM11_106 vout net050 vdd well_329 sg13_lv_pmos w=1u l=1u m=1
RT330 vdd well_330 ntap1 A=4e-12 P=8e-6
MM11_107 vout net050 vdd well_330 sg13_lv_pmos w=1u l=1u m=1
RT331 vdd well_331 ntap1 A=4e-12 P=8e-6
MM11_108 vout net050 vdd well_331 sg13_lv_pmos w=1u l=1u m=1
RT332 vdd well_332 ntap1 A=4e-12 P=8e-6
MM11_109 vout net050 vdd well_332 sg13_lv_pmos w=1u l=1u m=1
RT333 vdd well_333 ntap1 A=4e-12 P=8e-6
MM11_110 vout net050 vdd well_333 sg13_lv_pmos w=1u l=1u m=1
RT334 vdd well_334 ntap1 A=4e-12 P=8e-6
MM11_111 vout net050 vdd well_334 sg13_lv_pmos w=1u l=1u m=1
RT335 vdd well_335 ntap1 A=4e-12 P=8e-6
MM11_112 vout net050 vdd well_335 sg13_lv_pmos w=1u l=1u m=1
RT336 vdd well_336 ntap1 A=4e-12 P=8e-6
MM11_113 vout net050 vdd well_336 sg13_lv_pmos w=1u l=1u m=1
RT337 vdd well_337 ntap1 A=4e-12 P=8e-6
MM11_114 vout net050 vdd well_337 sg13_lv_pmos w=1u l=1u m=1
RT338 vdd well_338 ntap1 A=4e-12 P=8e-6
MM11_115 vout net050 vdd well_338 sg13_lv_pmos w=1u l=1u m=1
RT339 vdd well_339 ntap1 A=4e-12 P=8e-6
MM11_116 vout net050 vdd well_339 sg13_lv_pmos w=1u l=1u m=1
RT340 vdd well_340 ntap1 A=4e-12 P=8e-6
MM11_117 vout net050 vdd well_340 sg13_lv_pmos w=1u l=1u m=1
RT341 vdd well_341 ntap1 A=4e-12 P=8e-6
MM11_118 vout net050 vdd well_341 sg13_lv_pmos w=1u l=1u m=1
RT342 vdd well_342 ntap1 A=4e-12 P=8e-6
MM11_119 vout net050 vdd well_342 sg13_lv_pmos w=1u l=1u m=1
RT343 vdd well_343 ntap1 A=4e-12 P=8e-6
MM11_120 vout net050 vdd well_343 sg13_lv_pmos w=1u l=1u m=1
RT344 vdd well_344 ntap1 A=4e-12 P=8e-6
MM11_121 vout net050 vdd well_344 sg13_lv_pmos w=1u l=1u m=1
RT345 vdd well_345 ntap1 A=4e-12 P=8e-6
MM11_122 vout net050 vdd well_345 sg13_lv_pmos w=1u l=1u m=1
RT346 vdd well_346 ntap1 A=4e-12 P=8e-6
MM11_123 vout net050 vdd well_346 sg13_lv_pmos w=1u l=1u m=1
RT347 vdd well_347 ntap1 A=4e-12 P=8e-6
MM11_124 vout net050 vdd well_347 sg13_lv_pmos w=1u l=1u m=1
RT348 vdd well_348 ntap1 A=4e-12 P=8e-6
MM11_125 vout net050 vdd well_348 sg13_lv_pmos w=1u l=1u m=1
RT349 vdd well_349 ntap1 A=4e-12 P=8e-6
MM11_126 vout net050 vdd well_349 sg13_lv_pmos w=1u l=1u m=1
RT350 vdd well_350 ntap1 A=4e-12 P=8e-6
MM11_127 vout net050 vdd well_350 sg13_lv_pmos w=1u l=1u m=1
RT351 vdd well_351 ntap1 A=4e-12 P=8e-6
MM11_128 vout net050 vdd well_351 sg13_lv_pmos w=1u l=1u m=1
RT352 vdd well_352 ntap1 A=4e-12 P=8e-6
MM11_129 vout net050 vdd well_352 sg13_lv_pmos w=1u l=1u m=1
RT353 vdd well_353 ntap1 A=4e-12 P=8e-6
MM11_130 vout net050 vdd well_353 sg13_lv_pmos w=1u l=1u m=1
RT354 vdd well_354 ntap1 A=4e-12 P=8e-6
MM11_131 vout net050 vdd well_354 sg13_lv_pmos w=1u l=1u m=1
RT355 vdd well_355 ntap1 A=4e-12 P=8e-6
MM11_132 vout net050 vdd well_355 sg13_lv_pmos w=1u l=1u m=1
RT356 vdd well_356 ntap1 A=4e-12 P=8e-6
MM11_133 vout net050 vdd well_356 sg13_lv_pmos w=1u l=1u m=1
RT357 vdd well_357 ntap1 A=4e-12 P=8e-6
MM11_134 vout net050 vdd well_357 sg13_lv_pmos w=1u l=1u m=1
RT358 vdd well_358 ntap1 A=4e-12 P=8e-6
MM11_135 vout net050 vdd well_358 sg13_lv_pmos w=1u l=1u m=1
RT359 vdd well_359 ntap1 A=4e-12 P=8e-6
MM11_136 vout net050 vdd well_359 sg13_lv_pmos w=1u l=1u m=1
RT360 vdd well_360 ntap1 A=4e-12 P=8e-6
MM11_137 vout net050 vdd well_360 sg13_lv_pmos w=1u l=1u m=1
RT361 vdd well_361 ntap1 A=4e-12 P=8e-6
MM11_138 vout net050 vdd well_361 sg13_lv_pmos w=1u l=1u m=1
RT362 vdd well_362 ntap1 A=4e-12 P=8e-6
MM11_139 vout net050 vdd well_362 sg13_lv_pmos w=1u l=1u m=1
RT363 vdd well_363 ntap1 A=4e-12 P=8e-6
MM11_140 vout net050 vdd well_363 sg13_lv_pmos w=1u l=1u m=1
RT364 vdd well_364 ntap1 A=4e-12 P=8e-6
MM11_141 vout net050 vdd well_364 sg13_lv_pmos w=1u l=1u m=1
RT365 vdd well_365 ntap1 A=4e-12 P=8e-6
MM11_142 vout net050 vdd well_365 sg13_lv_pmos w=1u l=1u m=1
RT366 vdd well_366 ntap1 A=4e-12 P=8e-6
MM11_143 vout net050 vdd well_366 sg13_lv_pmos w=1u l=1u m=1
RT367 vdd well_367 ntap1 A=4e-12 P=8e-6
MM11_144 vout net050 vdd well_367 sg13_lv_pmos w=1u l=1u m=1
RT368 vdd well_368 ntap1 A=4e-12 P=8e-6
MM11_145 vout net050 vdd well_368 sg13_lv_pmos w=1u l=1u m=1
RT369 vdd well_369 ntap1 A=4e-12 P=8e-6
MM11_146 vout net050 vdd well_369 sg13_lv_pmos w=1u l=1u m=1
RT370 vdd well_370 ntap1 A=4e-12 P=8e-6
MM11_147 vout net050 vdd well_370 sg13_lv_pmos w=1u l=1u m=1
RT371 vdd well_371 ntap1 A=4e-12 P=8e-6
MM11_148 vout net050 vdd well_371 sg13_lv_pmos w=1u l=1u m=1
RT372 vdd well_372 ntap1 A=4e-12 P=8e-6
MM11_149 vout net050 vdd well_372 sg13_lv_pmos w=1u l=1u m=1
RT373 vdd well_373 ntap1 A=4e-12 P=8e-6
MM11_150 vout net050 vdd well_373 sg13_lv_pmos w=1u l=1u m=1
RT374 vdd well_374 ntap1 A=4e-12 P=8e-6
MM11_151 vout net050 vdd well_374 sg13_lv_pmos w=1u l=1u m=1
RT375 vdd well_375 ntap1 A=4e-12 P=8e-6
MM11_152 vout net050 vdd well_375 sg13_lv_pmos w=1u l=1u m=1
RT376 vdd well_376 ntap1 A=4e-12 P=8e-6
MM11_153 vout net050 vdd well_376 sg13_lv_pmos w=1u l=1u m=1
RT377 vdd well_377 ntap1 A=4e-12 P=8e-6
MM11_154 vout net050 vdd well_377 sg13_lv_pmos w=1u l=1u m=1
RT378 vdd well_378 ntap1 A=4e-12 P=8e-6
MM11_155 vout net050 vdd well_378 sg13_lv_pmos w=1u l=1u m=1
RT379 vdd well_379 ntap1 A=4e-12 P=8e-6
MM11_156 vout net050 vdd well_379 sg13_lv_pmos w=1u l=1u m=1
RT380 vdd well_380 ntap1 A=4e-12 P=8e-6
MM11_157 vout net050 vdd well_380 sg13_lv_pmos w=1u l=1u m=1
RT381 vdd well_381 ntap1 A=4e-12 P=8e-6
MM11_158 vout net050 vdd well_381 sg13_lv_pmos w=1u l=1u m=1
RT382 vdd well_382 ntap1 A=4e-12 P=8e-6
MM11_159 vout net050 vdd well_382 sg13_lv_pmos w=1u l=1u m=1
RT383 vdd well_383 ntap1 A=4e-12 P=8e-6
MM11_160 vout net050 vdd well_383 sg13_lv_pmos w=1u l=1u m=1
RT384 vdd well_384 ntap1 A=4e-12 P=8e-6
MM11_161 vout net050 vdd well_384 sg13_lv_pmos w=1u l=1u m=1
RT385 vdd well_385 ntap1 A=4e-12 P=8e-6
MM11_162 vout net050 vdd well_385 sg13_lv_pmos w=1u l=1u m=1
RT386 vdd well_386 ntap1 A=4e-12 P=8e-6
MM11_163 vout net050 vdd well_386 sg13_lv_pmos w=1u l=1u m=1
RT387 vdd well_387 ntap1 A=4e-12 P=8e-6
MM11_164 vout net050 vdd well_387 sg13_lv_pmos w=1u l=1u m=1
RT388 vdd well_388 ntap1 A=4e-12 P=8e-6
MM11_165 vout net050 vdd well_388 sg13_lv_pmos w=1u l=1u m=1
RT389 vdd well_389 ntap1 A=4e-12 P=8e-6
MM11_166 vout net050 vdd well_389 sg13_lv_pmos w=1u l=1u m=1
RT390 vdd well_390 ntap1 A=4e-12 P=8e-6
MM11_167 vout net050 vdd well_390 sg13_lv_pmos w=1u l=1u m=1
RT391 vdd well_391 ntap1 A=4e-12 P=8e-6
MM11_168 vout net050 vdd well_391 sg13_lv_pmos w=1u l=1u m=1
RT392 vdd well_392 ntap1 A=4e-12 P=8e-6
MM11_169 vout net050 vdd well_392 sg13_lv_pmos w=1u l=1u m=1
RT393 vdd well_393 ntap1 A=4e-12 P=8e-6
MM11_170 vout net050 vdd well_393 sg13_lv_pmos w=1u l=1u m=1
RT394 vdd well_394 ntap1 A=4e-12 P=8e-6
MM11_171 vout net050 vdd well_394 sg13_lv_pmos w=1u l=1u m=1
RT395 vdd well_395 ntap1 A=4e-12 P=8e-6
MM11_172 vout net050 vdd well_395 sg13_lv_pmos w=1u l=1u m=1
RT396 vdd well_396 ntap1 A=4e-12 P=8e-6
MM11_173 vout net050 vdd well_396 sg13_lv_pmos w=1u l=1u m=1
RT397 vdd well_397 ntap1 A=4e-12 P=8e-6
MM11_174 vout net050 vdd well_397 sg13_lv_pmos w=1u l=1u m=1
RT398 vdd well_398 ntap1 A=4e-12 P=8e-6
MM11_175 vout net050 vdd well_398 sg13_lv_pmos w=1u l=1u m=1
RT399 vdd well_399 ntap1 A=4e-12 P=8e-6
MM11_176 vout net050 vdd well_399 sg13_lv_pmos w=1u l=1u m=1
RT400 vdd well_400 ntap1 A=4e-12 P=8e-6
MM11_177 vout net050 vdd well_400 sg13_lv_pmos w=1u l=1u m=1
RT401 vdd well_401 ntap1 A=4e-12 P=8e-6
MM11_178 vout net050 vdd well_401 sg13_lv_pmos w=1u l=1u m=1
RT402 vdd well_402 ntap1 A=4e-12 P=8e-6
MM11_179 vout net050 vdd well_402 sg13_lv_pmos w=1u l=1u m=1
RT403 vdd well_403 ntap1 A=4e-12 P=8e-6
MM11_180 vout net050 vdd well_403 sg13_lv_pmos w=1u l=1u m=1
RT404 vdd well_404 ntap1 A=4e-12 P=8e-6
MM11_181 vout net050 vdd well_404 sg13_lv_pmos w=1u l=1u m=1
RT405 vdd well_405 ntap1 A=4e-12 P=8e-6
MM11_182 vout net050 vdd well_405 sg13_lv_pmos w=1u l=1u m=1
RT406 vdd well_406 ntap1 A=4e-12 P=8e-6
MM11_183 vout net050 vdd well_406 sg13_lv_pmos w=1u l=1u m=1
RT407 vdd well_407 ntap1 A=4e-12 P=8e-6
MM11_184 vout net050 vdd well_407 sg13_lv_pmos w=1u l=1u m=1
RT408 vdd well_408 ntap1 A=4e-12 P=8e-6
MM11_185 vout net050 vdd well_408 sg13_lv_pmos w=1u l=1u m=1
RT409 vdd well_409 ntap1 A=4e-12 P=8e-6
MM11_186 vout net050 vdd well_409 sg13_lv_pmos w=1u l=1u m=1
RT410 vdd well_410 ntap1 A=4e-12 P=8e-6
MM11_187 vout net050 vdd well_410 sg13_lv_pmos w=1u l=1u m=1
RT411 vdd well_411 ntap1 A=4e-12 P=8e-6
MM11_188 vout net050 vdd well_411 sg13_lv_pmos w=1u l=1u m=1
RT412 vdd well_412 ntap1 A=4e-12 P=8e-6
MM11_189 vout net050 vdd well_412 sg13_lv_pmos w=1u l=1u m=1
RT413 vdd well_413 ntap1 A=4e-12 P=8e-6
MM11_190 vout net050 vdd well_413 sg13_lv_pmos w=1u l=1u m=1
RT414 vdd well_414 ntap1 A=4e-12 P=8e-6
MM11_191 vout net050 vdd well_414 sg13_lv_pmos w=1u l=1u m=1
RT415 vdd well_415 ntap1 A=4e-12 P=8e-6
MM11_192 vout net050 vdd well_415 sg13_lv_pmos w=1u l=1u m=1
RT416 vdd well_416 ntap1 A=4e-12 P=8e-6
MM11_193 vout net050 vdd well_416 sg13_lv_pmos w=1u l=1u m=1
RT417 vdd well_417 ntap1 A=4e-12 P=8e-6
MM11_194 vout net050 vdd well_417 sg13_lv_pmos w=1u l=1u m=1
RT418 vdd well_418 ntap1 A=4e-12 P=8e-6
MM11_195 vout net050 vdd well_418 sg13_lv_pmos w=1u l=1u m=1
RT419 vdd well_419 ntap1 A=4e-12 P=8e-6
MM11_196 vout net050 vdd well_419 sg13_lv_pmos w=1u l=1u m=1
RT420 vdd well_420 ntap1 A=4e-12 P=8e-6
MM11_197 vout net050 vdd well_420 sg13_lv_pmos w=1u l=1u m=1
RT421 vdd well_421 ntap1 A=4e-12 P=8e-6
MM11_198 vout net050 vdd well_421 sg13_lv_pmos w=1u l=1u m=1
RT422 vdd well_422 ntap1 A=4e-12 P=8e-6
MM11_199 vout net050 vdd well_422 sg13_lv_pmos w=1u l=1u m=1
RT423 vdd well_423 ntap1 A=4e-12 P=8e-6
MM11_200 vout net050 vdd well_423 sg13_lv_pmos w=1u l=1u m=1
RT424 vdd well_424 ntap1 A=4e-12 P=8e-6
MM11_201 vout net050 vdd well_424 sg13_lv_pmos w=1u l=1u m=1
RT425 vdd well_425 ntap1 A=4e-12 P=8e-6
MM11_202 vout net050 vdd well_425 sg13_lv_pmos w=1u l=1u m=1
RT426 vdd well_426 ntap1 A=4e-12 P=8e-6
MM11_203 vout net050 vdd well_426 sg13_lv_pmos w=1u l=1u m=1
RT427 vdd well_427 ntap1 A=4e-12 P=8e-6
MM11_204 vout net050 vdd well_427 sg13_lv_pmos w=1u l=1u m=1
RT428 vdd well_428 ntap1 A=4e-12 P=8e-6
MM11_205 vout net050 vdd well_428 sg13_lv_pmos w=1u l=1u m=1
RT429 vdd well_429 ntap1 A=4e-12 P=8e-6
MM11_206 vout net050 vdd well_429 sg13_lv_pmos w=1u l=1u m=1
RT430 vdd well_430 ntap1 A=4e-12 P=8e-6
MM11_207 vout net050 vdd well_430 sg13_lv_pmos w=1u l=1u m=1
RT431 vdd well_431 ntap1 A=4e-12 P=8e-6
MM11_208 vout net050 vdd well_431 sg13_lv_pmos w=1u l=1u m=1
RT432 vdd well_432 ntap1 A=4e-12 P=8e-6
MM11_209 vout net050 vdd well_432 sg13_lv_pmos w=1u l=1u m=1
RT433 vdd well_433 ntap1 A=4e-12 P=8e-6
MM11_210 vout net050 vdd well_433 sg13_lv_pmos w=1u l=1u m=1
RT434 vdd well_434 ntap1 A=4e-12 P=8e-6
MM11_211 vout net050 vdd well_434 sg13_lv_pmos w=1u l=1u m=1
RT435 vdd well_435 ntap1 A=4e-12 P=8e-6
MM11_212 vout net050 vdd well_435 sg13_lv_pmos w=1u l=1u m=1
RT436 vdd well_436 ntap1 A=4e-12 P=8e-6
MM11_213 vout net050 vdd well_436 sg13_lv_pmos w=1u l=1u m=1
RT437 vdd well_437 ntap1 A=4e-12 P=8e-6
MM11_214 vout net050 vdd well_437 sg13_lv_pmos w=1u l=1u m=1
RT438 vdd well_438 ntap1 A=4e-12 P=8e-6
MM11_215 vout net050 vdd well_438 sg13_lv_pmos w=1u l=1u m=1
RT439 vdd well_439 ntap1 A=4e-12 P=8e-6
MM11_216 vout net050 vdd well_439 sg13_lv_pmos w=1u l=1u m=1
RT440 vdd well_440 ntap1 A=4e-12 P=8e-6
MM11_217 vout net050 vdd well_440 sg13_lv_pmos w=1u l=1u m=1
RT441 vdd well_441 ntap1 A=4e-12 P=8e-6
MM11_218 vout net050 vdd well_441 sg13_lv_pmos w=1u l=1u m=1
RT442 vdd well_442 ntap1 A=4e-12 P=8e-6
MM11_219 vout net050 vdd well_442 sg13_lv_pmos w=1u l=1u m=1
RT443 vdd well_443 ntap1 A=4e-12 P=8e-6
MM11_220 vout net050 vdd well_443 sg13_lv_pmos w=1u l=1u m=1
RT444 vdd well_444 ntap1 A=4e-12 P=8e-6
MM11_221 vout net050 vdd well_444 sg13_lv_pmos w=1u l=1u m=1
RT445 vdd well_445 ntap1 A=4e-12 P=8e-6
MM11_222 vout net050 vdd well_445 sg13_lv_pmos w=1u l=1u m=1
RT446 vdd well_446 ntap1 A=4e-12 P=8e-6
MM11_223 vout net050 vdd well_446 sg13_lv_pmos w=1u l=1u m=1
RT447 vdd well_447 ntap1 A=4e-12 P=8e-6
MM11_224 vout net050 vdd well_447 sg13_lv_pmos w=1u l=1u m=1
RT448 vdd well_448 ntap1 A=4e-12 P=8e-6
MM11_225 vout net050 vdd well_448 sg13_lv_pmos w=1u l=1u m=1
RT449 vdd well_449 ntap1 A=4e-12 P=8e-6
MM11_226 vout net050 vdd well_449 sg13_lv_pmos w=1u l=1u m=1
RT450 vdd well_450 ntap1 A=4e-12 P=8e-6
MM11_227 vout net050 vdd well_450 sg13_lv_pmos w=1u l=1u m=1
RT451 vdd well_451 ntap1 A=4e-12 P=8e-6
MM11_228 vout net050 vdd well_451 sg13_lv_pmos w=1u l=1u m=1
RT452 vdd well_452 ntap1 A=4e-12 P=8e-6
MM11_229 vout net050 vdd well_452 sg13_lv_pmos w=1u l=1u m=1
RT453 vdd well_453 ntap1 A=4e-12 P=8e-6
MM11_230 vout net050 vdd well_453 sg13_lv_pmos w=1u l=1u m=1
RT454 vdd well_454 ntap1 A=4e-12 P=8e-6
MM11_231 vout net050 vdd well_454 sg13_lv_pmos w=1u l=1u m=1
RT455 vdd well_455 ntap1 A=4e-12 P=8e-6
MM11_232 vout net050 vdd well_455 sg13_lv_pmos w=1u l=1u m=1
RT456 vdd well_456 ntap1 A=4e-12 P=8e-6
MM11_233 vout net050 vdd well_456 sg13_lv_pmos w=1u l=1u m=1
RT457 vdd well_457 ntap1 A=4e-12 P=8e-6
MM11_234 vout net050 vdd well_457 sg13_lv_pmos w=1u l=1u m=1
RT458 vdd well_458 ntap1 A=4e-12 P=8e-6
MM11_235 vout net050 vdd well_458 sg13_lv_pmos w=1u l=1u m=1
RT459 vdd well_459 ntap1 A=4e-12 P=8e-6
MM11_236 vout net050 vdd well_459 sg13_lv_pmos w=1u l=1u m=1
RT460 vdd well_460 ntap1 A=4e-12 P=8e-6
MM11_237 vout net050 vdd well_460 sg13_lv_pmos w=1u l=1u m=1
RT461 vdd well_461 ntap1 A=4e-12 P=8e-6
MM11_238 vout net050 vdd well_461 sg13_lv_pmos w=1u l=1u m=1
RT462 vdd well_462 ntap1 A=4e-12 P=8e-6
MM11_239 vout net050 vdd well_462 sg13_lv_pmos w=1u l=1u m=1
RT463 vdd well_463 ntap1 A=4e-12 P=8e-6
MM11_240 vout net050 vdd well_463 sg13_lv_pmos w=1u l=1u m=1
RT464 vdd well_464 ntap1 A=4e-12 P=8e-6
MM11_241 vout net050 vdd well_464 sg13_lv_pmos w=1u l=1u m=1
RT465 vdd well_465 ntap1 A=4e-12 P=8e-6
MM11_242 vout net050 vdd well_465 sg13_lv_pmos w=1u l=1u m=1
RT466 vdd well_466 ntap1 A=4e-12 P=8e-6
MM11_243 vout net050 vdd well_466 sg13_lv_pmos w=1u l=1u m=1
RT467 vdd well_467 ntap1 A=4e-12 P=8e-6
MM11_244 vout net050 vdd well_467 sg13_lv_pmos w=1u l=1u m=1
RT468 vdd well_468 ntap1 A=4e-12 P=8e-6
MM11_245 vout net050 vdd well_468 sg13_lv_pmos w=1u l=1u m=1
RT469 vdd well_469 ntap1 A=4e-12 P=8e-6
MM11_246 vout net050 vdd well_469 sg13_lv_pmos w=1u l=1u m=1
RT470 vdd well_470 ntap1 A=4e-12 P=8e-6
MM11_247 vout net050 vdd well_470 sg13_lv_pmos w=1u l=1u m=1
RT471 vdd well_471 ntap1 A=4e-12 P=8e-6
MM11_248 vout net050 vdd well_471 sg13_lv_pmos w=1u l=1u m=1
RT472 vdd well_472 ntap1 A=4e-12 P=8e-6
MM11_249 vout net050 vdd well_472 sg13_lv_pmos w=1u l=1u m=1
RT473 vdd well_473 ntap1 A=4e-12 P=8e-6
MM11_250 vout net050 vdd well_473 sg13_lv_pmos w=1u l=1u m=1
RT474 vdd well_474 ntap1 A=4e-12 P=8e-6
MM11_251 vout net050 vdd well_474 sg13_lv_pmos w=1u l=1u m=1
RT475 vdd well_475 ntap1 A=4e-12 P=8e-6
MM11_252 vout net050 vdd well_475 sg13_lv_pmos w=1u l=1u m=1
RT476 vdd well_476 ntap1 A=4e-12 P=8e-6
MM11_253 vout net050 vdd well_476 sg13_lv_pmos w=1u l=1u m=1
RT477 vdd well_477 ntap1 A=4e-12 P=8e-6
MM11_254 vout net050 vdd well_477 sg13_lv_pmos w=1u l=1u m=1
RT478 vdd well_478 ntap1 A=4e-12 P=8e-6
MM11_255 vout net050 vdd well_478 sg13_lv_pmos w=1u l=1u m=1
RT479 vdd well_479 ntap1 A=4e-12 P=8e-6
MM11_256 vout net050 vdd well_479 sg13_lv_pmos w=1u l=1u m=1
RT480 vdd well_480 ntap1 A=4e-12 P=8e-6
MM11_257 vout net050 vdd well_480 sg13_lv_pmos w=1u l=1u m=1
RT481 vdd well_481 ntap1 A=4e-12 P=8e-6
MM11_258 vout net050 vdd well_481 sg13_lv_pmos w=1u l=1u m=1
RT482 vdd well_482 ntap1 A=4e-12 P=8e-6
MM11_259 vout net050 vdd well_482 sg13_lv_pmos w=1u l=1u m=1
RT483 vdd well_483 ntap1 A=4e-12 P=8e-6
MM11_260 vout net050 vdd well_483 sg13_lv_pmos w=1u l=1u m=1
RT484 vdd well_484 ntap1 A=4e-12 P=8e-6
MM11_261 vout net050 vdd well_484 sg13_lv_pmos w=1u l=1u m=1
RT485 vdd well_485 ntap1 A=4e-12 P=8e-6
MM11_262 vout net050 vdd well_485 sg13_lv_pmos w=1u l=1u m=1
RT486 vdd well_486 ntap1 A=4e-12 P=8e-6
MM11_263 vout net050 vdd well_486 sg13_lv_pmos w=1u l=1u m=1
RT487 vdd well_487 ntap1 A=4e-12 P=8e-6
MM11_264 vout net050 vdd well_487 sg13_lv_pmos w=1u l=1u m=1
RT488 vdd well_488 ntap1 A=4e-12 P=8e-6
MM11_265 vout net050 vdd well_488 sg13_lv_pmos w=1u l=1u m=1
RT489 vdd well_489 ntap1 A=4e-12 P=8e-6
MM11_266 vout net050 vdd well_489 sg13_lv_pmos w=1u l=1u m=1
RT490 vdd well_490 ntap1 A=4e-12 P=8e-6
MM11_267 vout net050 vdd well_490 sg13_lv_pmos w=1u l=1u m=1
RT491 vdd well_491 ntap1 A=4e-12 P=8e-6
MM11_268 vout net050 vdd well_491 sg13_lv_pmos w=1u l=1u m=1
RT492 vdd well_492 ntap1 A=4e-12 P=8e-6
MM11_269 vout net050 vdd well_492 sg13_lv_pmos w=1u l=1u m=1
RT493 vdd well_493 ntap1 A=4e-12 P=8e-6
MM11_270 vout net050 vdd well_493 sg13_lv_pmos w=1u l=1u m=1
RT494 vdd well_494 ntap1 A=4e-12 P=8e-6
MM11_271 vout net050 vdd well_494 sg13_lv_pmos w=1u l=1u m=1
RT495 vdd well_495 ntap1 A=4e-12 P=8e-6
MM11_272 vout net050 vdd well_495 sg13_lv_pmos w=1u l=1u m=1
RT496 vdd well_496 ntap1 A=4e-12 P=8e-6
MM11_273 vout net050 vdd well_496 sg13_lv_pmos w=1u l=1u m=1
RT497 vdd well_497 ntap1 A=4e-12 P=8e-6
MM11_274 vout net050 vdd well_497 sg13_lv_pmos w=1u l=1u m=1
RT498 vdd well_498 ntap1 A=4e-12 P=8e-6
MM11_275 vout net050 vdd well_498 sg13_lv_pmos w=1u l=1u m=1
RT499 vdd well_499 ntap1 A=4e-12 P=8e-6
MM11_276 vout net050 vdd well_499 sg13_lv_pmos w=1u l=1u m=1
RT500 vdd well_500 ntap1 A=4e-12 P=8e-6
MM11_277 vout net050 vdd well_500 sg13_lv_pmos w=1u l=1u m=1
RT501 vdd well_501 ntap1 A=4e-12 P=8e-6
MM11_278 vout net050 vdd well_501 sg13_lv_pmos w=1u l=1u m=1
RT502 vdd well_502 ntap1 A=4e-12 P=8e-6
MM11_279 vout net050 vdd well_502 sg13_lv_pmos w=1u l=1u m=1
RT503 vdd well_503 ntap1 A=4e-12 P=8e-6
MM11_280 vout net050 vdd well_503 sg13_lv_pmos w=1u l=1u m=1
RT504 vdd well_504 ntap1 A=4e-12 P=8e-6
MM11_281 vout net050 vdd well_504 sg13_lv_pmos w=1u l=1u m=1
RT505 vdd well_505 ntap1 A=4e-12 P=8e-6
MM11_282 vout net050 vdd well_505 sg13_lv_pmos w=1u l=1u m=1
RT506 vdd well_506 ntap1 A=4e-12 P=8e-6
MM11_283 vout net050 vdd well_506 sg13_lv_pmos w=1u l=1u m=1
RT507 vdd well_507 ntap1 A=4e-12 P=8e-6
MM11_284 vout net050 vdd well_507 sg13_lv_pmos w=1u l=1u m=1
RT508 vdd well_508 ntap1 A=4e-12 P=8e-6
MM11_285 vout net050 vdd well_508 sg13_lv_pmos w=1u l=1u m=1
RT509 vdd well_509 ntap1 A=4e-12 P=8e-6
MM11_286 vout net050 vdd well_509 sg13_lv_pmos w=1u l=1u m=1
RT510 vdd well_510 ntap1 A=4e-12 P=8e-6
MM11_287 vout net050 vdd well_510 sg13_lv_pmos w=1u l=1u m=1
RT511 vdd well_511 ntap1 A=4e-12 P=8e-6
MM11_288 vout net050 vdd well_511 sg13_lv_pmos w=1u l=1u m=1
RT512 vdd well_512 ntap1 A=4e-12 P=8e-6
MM11_289 vout net050 vdd well_512 sg13_lv_pmos w=1u l=1u m=1
RT513 vdd well_513 ntap1 A=4e-12 P=8e-6
MM11_290 vout net050 vdd well_513 sg13_lv_pmos w=1u l=1u m=1
RT514 vdd well_514 ntap1 A=4e-12 P=8e-6
MM11_291 vout net050 vdd well_514 sg13_lv_pmos w=1u l=1u m=1
RT515 vdd well_515 ntap1 A=4e-12 P=8e-6
MM11_292 vout net050 vdd well_515 sg13_lv_pmos w=1u l=1u m=1
RT516 vdd well_516 ntap1 A=4e-12 P=8e-6
MM11_293 vout net050 vdd well_516 sg13_lv_pmos w=1u l=1u m=1
RT517 vdd well_517 ntap1 A=4e-12 P=8e-6
MM11_294 vout net050 vdd well_517 sg13_lv_pmos w=1u l=1u m=1
RT518 vdd well_518 ntap1 A=4e-12 P=8e-6
MM11_295 vout net050 vdd well_518 sg13_lv_pmos w=1u l=1u m=1
RT519 vdd well_519 ntap1 A=4e-12 P=8e-6
MM11_296 vout net050 vdd well_519 sg13_lv_pmos w=1u l=1u m=1
RT520 vdd well_520 ntap1 A=4e-12 P=8e-6
MM11_297 vout net050 vdd well_520 sg13_lv_pmos w=1u l=1u m=1
RT521 vdd well_521 ntap1 A=4e-12 P=8e-6
MM11_298 vout net050 vdd well_521 sg13_lv_pmos w=1u l=1u m=1
RT522 vdd well_522 ntap1 A=4e-12 P=8e-6
MM11_299 vout net050 vdd well_522 sg13_lv_pmos w=1u l=1u m=1
RT523 vdd well_523 ntap1 A=4e-12 P=8e-6
MM11_300 vout net050 vdd well_523 sg13_lv_pmos w=1u l=1u m=1
RT524 vdd well_524 ntap1 A=4e-12 P=8e-6
MM11_301 vout net050 vdd well_524 sg13_lv_pmos w=1u l=1u m=1
RT525 vdd well_525 ntap1 A=4e-12 P=8e-6
MM11_302 vout net050 vdd well_525 sg13_lv_pmos w=1u l=1u m=1
RT526 vdd well_526 ntap1 A=4e-12 P=8e-6
MM11_303 vout net050 vdd well_526 sg13_lv_pmos w=1u l=1u m=1
RT527 vdd well_527 ntap1 A=4e-12 P=8e-6
MM11_304 vout net050 vdd well_527 sg13_lv_pmos w=1u l=1u m=1
RT528 vdd well_528 ntap1 A=4e-12 P=8e-6
MM11_305 vout net050 vdd well_528 sg13_lv_pmos w=1u l=1u m=1
RT529 vdd well_529 ntap1 A=4e-12 P=8e-6
MM11_306 vout net050 vdd well_529 sg13_lv_pmos w=1u l=1u m=1
RT530 vdd well_530 ntap1 A=4e-12 P=8e-6
MM11_307 vout net050 vdd well_530 sg13_lv_pmos w=1u l=1u m=1
RT531 vdd well_531 ntap1 A=4e-12 P=8e-6
MM11_308 vout net050 vdd well_531 sg13_lv_pmos w=1u l=1u m=1
RT532 vdd well_532 ntap1 A=4e-12 P=8e-6
MM11_309 vout net050 vdd well_532 sg13_lv_pmos w=1u l=1u m=1
RT533 vdd well_533 ntap1 A=4e-12 P=8e-6
MM11_310 vout net050 vdd well_533 sg13_lv_pmos w=1u l=1u m=1
RT534 vdd well_534 ntap1 A=4e-12 P=8e-6
MM11_311 vout net050 vdd well_534 sg13_lv_pmos w=1u l=1u m=1
RT535 vdd well_535 ntap1 A=4e-12 P=8e-6
MM11_312 vout net050 vdd well_535 sg13_lv_pmos w=1u l=1u m=1
RT536 vdd well_536 ntap1 A=4e-12 P=8e-6
MM11_313 vout net050 vdd well_536 sg13_lv_pmos w=1u l=1u m=1
RT537 vdd well_537 ntap1 A=4e-12 P=8e-6
MM11_314 vout net050 vdd well_537 sg13_lv_pmos w=1u l=1u m=1
RT538 vdd well_538 ntap1 A=4e-12 P=8e-6
MM11_315 vout net050 vdd well_538 sg13_lv_pmos w=1u l=1u m=1
RT539 vdd well_539 ntap1 A=4e-12 P=8e-6
MM11_316 vout net050 vdd well_539 sg13_lv_pmos w=1u l=1u m=1
RT540 vdd well_540 ntap1 A=4e-12 P=8e-6
MM11_317 vout net050 vdd well_540 sg13_lv_pmos w=1u l=1u m=1
RT541 vdd well_541 ntap1 A=4e-12 P=8e-6
MM11_318 vout net050 vdd well_541 sg13_lv_pmos w=1u l=1u m=1
RT542 vdd well_542 ntap1 A=4e-12 P=8e-6
MM11_319 vout net050 vdd well_542 sg13_lv_pmos w=1u l=1u m=1
RT543 vdd well_543 ntap1 A=4e-12 P=8e-6
MM11_320 vout net050 vdd well_543 sg13_lv_pmos w=1u l=1u m=1
RT544 vdd well_544 ntap1 A=4e-12 P=8e-6
MM11_321 vout net050 vdd well_544 sg13_lv_pmos w=1u l=1u m=1
RT545 vdd well_545 ntap1 A=4e-12 P=8e-6
MM11_322 vout net050 vdd well_545 sg13_lv_pmos w=1u l=1u m=1
RT546 vdd well_546 ntap1 A=4e-12 P=8e-6
MM11_323 vout net050 vdd well_546 sg13_lv_pmos w=1u l=1u m=1
RT547 vdd well_547 ntap1 A=4e-12 P=8e-6
MM11_324 vout net050 vdd well_547 sg13_lv_pmos w=1u l=1u m=1
RT548 vdd well_548 ntap1 A=4e-12 P=8e-6
MM11_325 vout net050 vdd well_548 sg13_lv_pmos w=1u l=1u m=1
RT549 vdd well_549 ntap1 A=4e-12 P=8e-6
MM11_326 vout net050 vdd well_549 sg13_lv_pmos w=1u l=1u m=1
RT550 vdd well_550 ntap1 A=4e-12 P=8e-6
MM11_327 vout net050 vdd well_550 sg13_lv_pmos w=1u l=1u m=1
RT551 vdd well_551 ntap1 A=4e-12 P=8e-6
MM11_328 vout net050 vdd well_551 sg13_lv_pmos w=1u l=1u m=1
RT552 vdd well_552 ntap1 A=4e-12 P=8e-6
MM11_329 vout net050 vdd well_552 sg13_lv_pmos w=1u l=1u m=1
RT553 vdd well_553 ntap1 A=4e-12 P=8e-6
MM11_330 vout net050 vdd well_553 sg13_lv_pmos w=1u l=1u m=1
RT554 vdd well_554 ntap1 A=4e-12 P=8e-6
MM11_331 vout net050 vdd well_554 sg13_lv_pmos w=1u l=1u m=1
RT555 vdd well_555 ntap1 A=4e-12 P=8e-6
MM11_332 vout net050 vdd well_555 sg13_lv_pmos w=1u l=1u m=1
RT556 vdd well_556 ntap1 A=4e-12 P=8e-6
MM11_333 vout net050 vdd well_556 sg13_lv_pmos w=1u l=1u m=1
RT557 vdd well_557 ntap1 A=4e-12 P=8e-6
MM11_334 vout net050 vdd well_557 sg13_lv_pmos w=1u l=1u m=1
RT558 vdd well_558 ntap1 A=4e-12 P=8e-6
MM11_335 vout net050 vdd well_558 sg13_lv_pmos w=1u l=1u m=1
RT559 vdd well_559 ntap1 A=4e-12 P=8e-6
MM11_336 vout net050 vdd well_559 sg13_lv_pmos w=1u l=1u m=1
RT560 vdd well_560 ntap1 A=4e-12 P=8e-6
MM11_337 vout net050 vdd well_560 sg13_lv_pmos w=1u l=1u m=1
RT561 vdd well_561 ntap1 A=4e-12 P=8e-6
MM11_338 vout net050 vdd well_561 sg13_lv_pmos w=1u l=1u m=1
RT562 vdd well_562 ntap1 A=4e-12 P=8e-6
MM11_339 vout net050 vdd well_562 sg13_lv_pmos w=1u l=1u m=1
RT563 vdd well_563 ntap1 A=4e-12 P=8e-6
MM11_340 vout net050 vdd well_563 sg13_lv_pmos w=1u l=1u m=1
RT564 vdd well_564 ntap1 A=4e-12 P=8e-6
MM11_341 vout net050 vdd well_564 sg13_lv_pmos w=1u l=1u m=1
RT565 vdd well_565 ntap1 A=4e-12 P=8e-6
MM11_342 vout net050 vdd well_565 sg13_lv_pmos w=1u l=1u m=1
RT566 vdd well_566 ntap1 A=4e-12 P=8e-6
MM11_343 vout net050 vdd well_566 sg13_lv_pmos w=1u l=1u m=1
RT567 vdd well_567 ntap1 A=4e-12 P=8e-6
MM11_344 vout net050 vdd well_567 sg13_lv_pmos w=1u l=1u m=1
RT568 vdd well_568 ntap1 A=4e-12 P=8e-6
MM11_345 vout net050 vdd well_568 sg13_lv_pmos w=1u l=1u m=1
RT569 vdd well_569 ntap1 A=4e-12 P=8e-6
MM11_346 vout net050 vdd well_569 sg13_lv_pmos w=1u l=1u m=1
RT570 vdd well_570 ntap1 A=4e-12 P=8e-6
MM11_347 vout net050 vdd well_570 sg13_lv_pmos w=1u l=1u m=1
RT571 vdd well_571 ntap1 A=4e-12 P=8e-6
MM11_348 vout net050 vdd well_571 sg13_lv_pmos w=1u l=1u m=1
RT572 vdd well_572 ntap1 A=4e-12 P=8e-6
MM11_349 vout net050 vdd well_572 sg13_lv_pmos w=1u l=1u m=1
RT573 vdd well_573 ntap1 A=4e-12 P=8e-6
MM11_350 vout net050 vdd well_573 sg13_lv_pmos w=1u l=1u m=1
RT574 vdd well_574 ntap1 A=4e-12 P=8e-6
MM11_351 vout net050 vdd well_574 sg13_lv_pmos w=1u l=1u m=1
RT575 vdd well_575 ntap1 A=4e-12 P=8e-6
MM11_352 vout net050 vdd well_575 sg13_lv_pmos w=1u l=1u m=1
RT576 vdd well_576 ntap1 A=4e-12 P=8e-6
MM11_353 vout net050 vdd well_576 sg13_lv_pmos w=1u l=1u m=1
RT577 vdd well_577 ntap1 A=4e-12 P=8e-6
MM11_354 vout net050 vdd well_577 sg13_lv_pmos w=1u l=1u m=1
RT578 vdd well_578 ntap1 A=4e-12 P=8e-6
MM11_355 vout net050 vdd well_578 sg13_lv_pmos w=1u l=1u m=1
RT579 vdd well_579 ntap1 A=4e-12 P=8e-6
MM11_356 vout net050 vdd well_579 sg13_lv_pmos w=1u l=1u m=1
RT580 vdd well_580 ntap1 A=4e-12 P=8e-6
MM11_357 vout net050 vdd well_580 sg13_lv_pmos w=1u l=1u m=1
RT581 vdd well_581 ntap1 A=4e-12 P=8e-6
MM11_358 vout net050 vdd well_581 sg13_lv_pmos w=1u l=1u m=1
RT582 vdd well_582 ntap1 A=4e-12 P=8e-6
MM11_359 vout net050 vdd well_582 sg13_lv_pmos w=1u l=1u m=1
RT583 vdd well_583 ntap1 A=4e-12 P=8e-6
MM11_360 vout net050 vdd well_583 sg13_lv_pmos w=1u l=1u m=1
RT584 vdd well_584 ntap1 A=4e-12 P=8e-6
MM11_361 vout net050 vdd well_584 sg13_lv_pmos w=1u l=1u m=1
RT585 vdd well_585 ntap1 A=4e-12 P=8e-6
MM11_362 vout net050 vdd well_585 sg13_lv_pmos w=1u l=1u m=1
RT586 vdd well_586 ntap1 A=4e-12 P=8e-6
MM11_363 vout net050 vdd well_586 sg13_lv_pmos w=1u l=1u m=1
RT587 vdd well_587 ntap1 A=4e-12 P=8e-6
MM11_364 vout net050 vdd well_587 sg13_lv_pmos w=1u l=1u m=1
RT588 vdd well_588 ntap1 A=4e-12 P=8e-6
MM11_365 vout net050 vdd well_588 sg13_lv_pmos w=1u l=1u m=1
RT589 vdd well_589 ntap1 A=4e-12 P=8e-6
MM11_366 vout net050 vdd well_589 sg13_lv_pmos w=1u l=1u m=1
RT590 vdd well_590 ntap1 A=4e-12 P=8e-6
MM11_367 vout net050 vdd well_590 sg13_lv_pmos w=1u l=1u m=1
RT591 vdd well_591 ntap1 A=4e-12 P=8e-6
MM11_368 vout net050 vdd well_591 sg13_lv_pmos w=1u l=1u m=1
RT592 vdd well_592 ntap1 A=4e-12 P=8e-6
MM11_369 vout net050 vdd well_592 sg13_lv_pmos w=1u l=1u m=1
RT593 vdd well_593 ntap1 A=4e-12 P=8e-6
MM11_370 vout net050 vdd well_593 sg13_lv_pmos w=1u l=1u m=1
RT594 vdd well_594 ntap1 A=4e-12 P=8e-6
MM11_371 vout net050 vdd well_594 sg13_lv_pmos w=1u l=1u m=1
RT595 vdd well_595 ntap1 A=4e-12 P=8e-6
MM11_372 vout net050 vdd well_595 sg13_lv_pmos w=1u l=1u m=1
RT596 vdd well_596 ntap1 A=4e-12 P=8e-6
MM11_373 vout net050 vdd well_596 sg13_lv_pmos w=1u l=1u m=1
RT597 vdd well_597 ntap1 A=4e-12 P=8e-6
MM11_374 vout net050 vdd well_597 sg13_lv_pmos w=1u l=1u m=1
RT598 vdd well_598 ntap1 A=4e-12 P=8e-6
MM11_375 vout net050 vdd well_598 sg13_lv_pmos w=1u l=1u m=1
RT599 vdd well_599 ntap1 A=4e-12 P=8e-6
MM11_376 vout net050 vdd well_599 sg13_lv_pmos w=1u l=1u m=1
RT600 vdd well_600 ntap1 A=4e-12 P=8e-6
MM11_377 vout net050 vdd well_600 sg13_lv_pmos w=1u l=1u m=1
RT601 vdd well_601 ntap1 A=4e-12 P=8e-6
MM11_378 vout net050 vdd well_601 sg13_lv_pmos w=1u l=1u m=1
RT602 vdd well_602 ntap1 A=4e-12 P=8e-6
MM11_379 vout net050 vdd well_602 sg13_lv_pmos w=1u l=1u m=1
RT603 vdd well_603 ntap1 A=4e-12 P=8e-6
MM11_380 vout net050 vdd well_603 sg13_lv_pmos w=1u l=1u m=1
RT604 vdd well_604 ntap1 A=4e-12 P=8e-6
MM11_381 vout net050 vdd well_604 sg13_lv_pmos w=1u l=1u m=1
RT605 vdd well_605 ntap1 A=4e-12 P=8e-6
MM11_382 vout net050 vdd well_605 sg13_lv_pmos w=1u l=1u m=1
RT606 vdd well_606 ntap1 A=4e-12 P=8e-6
MM11_383 vout net050 vdd well_606 sg13_lv_pmos w=1u l=1u m=1
RT607 vdd well_607 ntap1 A=4e-12 P=8e-6
MM11_384 vout net050 vdd well_607 sg13_lv_pmos w=1u l=1u m=1
RT608 vdd well_608 ntap1 A=4e-12 P=8e-6
MM11_385 vout net050 vdd well_608 sg13_lv_pmos w=1u l=1u m=1
RT609 vdd well_609 ntap1 A=4e-12 P=8e-6
MM11_386 vout net050 vdd well_609 sg13_lv_pmos w=1u l=1u m=1
RT610 vdd well_610 ntap1 A=4e-12 P=8e-6
MM11_387 vout net050 vdd well_610 sg13_lv_pmos w=1u l=1u m=1
RT611 vdd well_611 ntap1 A=4e-12 P=8e-6
MM11_388 vout net050 vdd well_611 sg13_lv_pmos w=1u l=1u m=1
RT612 vdd well_612 ntap1 A=4e-12 P=8e-6
MM11_389 vout net050 vdd well_612 sg13_lv_pmos w=1u l=1u m=1
RT613 vdd well_613 ntap1 A=4e-12 P=8e-6
MM11_390 vout net050 vdd well_613 sg13_lv_pmos w=1u l=1u m=1
RT614 vdd well_614 ntap1 A=4e-12 P=8e-6
MM11_391 vout net050 vdd well_614 sg13_lv_pmos w=1u l=1u m=1
RT615 vdd well_615 ntap1 A=4e-12 P=8e-6
MM11_392 vout net050 vdd well_615 sg13_lv_pmos w=1u l=1u m=1
RT616 vdd well_616 ntap1 A=4e-12 P=8e-6
MM11_393 vout net050 vdd well_616 sg13_lv_pmos w=1u l=1u m=1
RT617 vdd well_617 ntap1 A=4e-12 P=8e-6
MM11_394 vout net050 vdd well_617 sg13_lv_pmos w=1u l=1u m=1
RT618 vdd well_618 ntap1 A=4e-12 P=8e-6
MM11_395 vout net050 vdd well_618 sg13_lv_pmos w=1u l=1u m=1
RT619 vdd well_619 ntap1 A=4e-12 P=8e-6
MM11_396 vout net050 vdd well_619 sg13_lv_pmos w=1u l=1u m=1
RT620 vdd well_620 ntap1 A=4e-12 P=8e-6
MM11_397 vout net050 vdd well_620 sg13_lv_pmos w=1u l=1u m=1
RT621 vdd well_621 ntap1 A=4e-12 P=8e-6
MM11_398 vout net050 vdd well_621 sg13_lv_pmos w=1u l=1u m=1
RT622 vdd well_622 ntap1 A=4e-12 P=8e-6
MM11_399 vout net050 vdd well_622 sg13_lv_pmos w=1u l=1u m=1
RT623 vss sub ptap1 A=4e-12 P=8e-6
MM12_0 vb4 vb3 net54 sub sg13_lv_nmos w=1u l=1u m=1
RT624 vss sub ptap1 A=4e-12 P=8e-6
MM12_1 vb4 vb3 net54 sub sg13_lv_nmos w=1u l=1u m=1
RT625 vss sub ptap1 A=4e-12 P=8e-6
MM12_2 vb4 vb3 net54 sub sg13_lv_nmos w=1u l=1u m=1
RT626 vss sub ptap1 A=4e-12 P=8e-6
MM12_3 vb4 vb3 net54 sub sg13_lv_nmos w=1u l=1u m=1
RT627 vss sub ptap1 A=4e-12 P=8e-6
MM12_4 vb4 vb3 net54 sub sg13_lv_nmos w=1u l=1u m=1
RT628 vss sub ptap1 A=4e-12 P=8e-6
MM12_5 vb4 vb3 net54 sub sg13_lv_nmos w=1u l=1u m=1
RT629 vss sub ptap1 A=4e-12 P=8e-6
MM12_6 vb4 vb3 net54 sub sg13_lv_nmos w=1u l=1u m=1
RT630 vss sub ptap1 A=4e-12 P=8e-6
MM12_7 vb4 vb3 net54 sub sg13_lv_nmos w=1u l=1u m=1
RT631 vss sub ptap1 A=4e-12 P=8e-6
MM12_8 vb4 vb3 net54 sub sg13_lv_nmos w=1u l=1u m=1
RT632 vss sub ptap1 A=4e-12 P=8e-6
MM12_9 vb4 vb3 net54 sub sg13_lv_nmos w=1u l=1u m=1
RT633 vss sub ptap1 A=4e-12 P=8e-6
MM12_10 vb4 vb3 net54 sub sg13_lv_nmos w=1u l=1u m=1
RT634 vss sub ptap1 A=4e-12 P=8e-6
MM12_11 vb4 vb3 net54 sub sg13_lv_nmos w=1u l=1u m=1
RT635 vss sub ptap1 A=4e-12 P=8e-6
MM12_12 vb4 vb3 net54 sub sg13_lv_nmos w=1u l=1u m=1
RT636 vss sub ptap1 A=4e-12 P=8e-6
MM12_13 vb4 vb3 net54 sub sg13_lv_nmos w=1u l=1u m=1
RT637 vss sub ptap1 A=4e-12 P=8e-6
MM12_14 vb4 vb3 net54 sub sg13_lv_nmos w=1u l=1u m=1
RT638 vss sub ptap1 A=4e-12 P=8e-6
MM12_15 vb4 vb3 net54 sub sg13_lv_nmos w=1u l=1u m=1
RT639 vss sub ptap1 A=4e-12 P=8e-6
MM12_16 vb4 vb3 net54 sub sg13_lv_nmos w=1u l=1u m=1
RT640 vss sub ptap1 A=4e-12 P=8e-6
MM12_17 vb4 vb3 net54 sub sg13_lv_nmos w=1u l=1u m=1
RT641 vss sub ptap1 A=4e-12 P=8e-6
MM12_18 vb4 vb3 net54 sub sg13_lv_nmos w=1u l=1u m=1
RT642 vss sub ptap1 A=4e-12 P=8e-6
MM12_19 vb4 vb3 net54 sub sg13_lv_nmos w=1u l=1u m=1
RT643 vss sub ptap1 A=4e-12 P=8e-6
MM12_20 vb4 vb3 net54 sub sg13_lv_nmos w=1u l=1u m=1
RT644 vss sub ptap1 A=4e-12 P=8e-6
MM12_21 vb4 vb3 net54 sub sg13_lv_nmos w=1u l=1u m=1
RT645 vss sub ptap1 A=4e-12 P=8e-6
MM12_22 vb4 vb3 net54 sub sg13_lv_nmos w=1u l=1u m=1
RT646 vss sub ptap1 A=4e-12 P=8e-6
MM12_23 vb4 vb3 net54 sub sg13_lv_nmos w=1u l=1u m=1
RT647 vss sub ptap1 A=4e-12 P=8e-6
MM12_24 vb4 vb3 net54 sub sg13_lv_nmos w=1u l=1u m=1
RT648 vss sub ptap1 A=4e-12 P=8e-6
MM12_25 vb4 vb3 net54 sub sg13_lv_nmos w=1u l=1u m=1
RT649 vss sub ptap1 A=4e-12 P=8e-6
MM12_26 vb4 vb3 net54 sub sg13_lv_nmos w=1u l=1u m=1
RT650 vss sub ptap1 A=4e-12 P=8e-6
MM12_27 vb4 vb3 net54 sub sg13_lv_nmos w=1u l=1u m=1
RT651 vss sub ptap1 A=4e-12 P=8e-6
MM12_28 vb4 vb3 net54 sub sg13_lv_nmos w=1u l=1u m=1
RT652 vss sub ptap1 A=4e-12 P=8e-6
MM12_29 vb4 vb3 net54 sub sg13_lv_nmos w=1u l=1u m=1
RT653 vss sub ptap1 A=4e-12 P=8e-6
MM12_30 vb4 vb3 net54 sub sg13_lv_nmos w=1u l=1u m=1
RT654 vss sub ptap1 A=4e-12 P=8e-6
MM12_31 vb4 vb3 net54 sub sg13_lv_nmos w=1u l=1u m=1
RT655 vss sub ptap1 A=4e-12 P=8e-6
MM12_32 vb4 vb3 net54 sub sg13_lv_nmos w=1u l=1u m=1
RT656 vss sub ptap1 A=4e-12 P=8e-6
MM12_33 vb4 vb3 net54 sub sg13_lv_nmos w=1u l=1u m=1
RT657 vss sub ptap1 A=4e-12 P=8e-6
MM12_34 vb4 vb3 net54 sub sg13_lv_nmos w=1u l=1u m=1
RT658 vss sub ptap1 A=4e-12 P=8e-6
MM12_35 vb4 vb3 net54 sub sg13_lv_nmos w=1u l=1u m=1
RT659 vss sub ptap1 A=4e-12 P=8e-6
MM12_36 vb4 vb3 net54 sub sg13_lv_nmos w=1u l=1u m=1
RT660 vss sub ptap1 A=4e-12 P=8e-6
MM12_37 vb4 vb3 net54 sub sg13_lv_nmos w=1u l=1u m=1
RT661 vss sub ptap1 A=4e-12 P=8e-6
MM12_38 vb4 vb3 net54 sub sg13_lv_nmos w=1u l=1u m=1
RT662 vss sub ptap1 A=4e-12 P=8e-6
MM12_39 vb4 vb3 net54 sub sg13_lv_nmos w=1u l=1u m=1
RT663 vss sub ptap1 A=4e-12 P=8e-6
MM12_40 vb4 vb3 net54 sub sg13_lv_nmos w=1u l=1u m=1
RT664 vss sub ptap1 A=4e-12 P=8e-6
MM12_41 vb4 vb3 net54 sub sg13_lv_nmos w=1u l=1u m=1
RT665 vss sub ptap1 A=4e-12 P=8e-6
MM12_42 vb4 vb3 net54 sub sg13_lv_nmos w=1u l=1u m=1
RT666 vss sub ptap1 A=4e-12 P=8e-6
MM12_43 vb4 vb3 net54 sub sg13_lv_nmos w=1u l=1u m=1
RT667 vss sub ptap1 A=4e-12 P=8e-6
MM12_44 vb4 vb3 net54 sub sg13_lv_nmos w=1u l=1u m=1
RT668 vss sub ptap1 A=4e-12 P=8e-6
MM12_45 vb4 vb3 net54 sub sg13_lv_nmos w=1u l=1u m=1
RT669 vss sub ptap1 A=4e-12 P=8e-6
MM12_46 vb4 vb3 net54 sub sg13_lv_nmos w=1u l=1u m=1
RT670 vss sub ptap1 A=4e-12 P=8e-6
MM12_47 vb4 vb3 net54 sub sg13_lv_nmos w=1u l=1u m=1
RT671 vss sub ptap1 A=4e-12 P=8e-6
MM12_48 vb4 vb3 net54 sub sg13_lv_nmos w=1u l=1u m=1
RT672 vss sub ptap1 A=4e-12 P=8e-6
MM12_49 vb4 vb3 net54 sub sg13_lv_nmos w=1u l=1u m=1
RT673 vss sub ptap1 A=4e-12 P=8e-6
MM12_50 vb4 vb3 net54 sub sg13_lv_nmos w=1u l=1u m=1
RT674 vss sub ptap1 A=4e-12 P=8e-6
MM12_51 vb4 vb3 net54 sub sg13_lv_nmos w=1u l=1u m=1
RT675 vss sub ptap1 A=4e-12 P=8e-6
MM12_52 vb4 vb3 net54 sub sg13_lv_nmos w=1u l=1u m=1
RT676 vss sub ptap1 A=4e-12 P=8e-6
MM12_53 vb4 vb3 net54 sub sg13_lv_nmos w=1u l=1u m=1
RT677 vss sub ptap1 A=4e-12 P=8e-6
MM12_54 vb4 vb3 net54 sub sg13_lv_nmos w=1u l=1u m=1
RT678 vss sub ptap1 A=4e-12 P=8e-6
MM12_55 vb4 vb3 net54 sub sg13_lv_nmos w=1u l=1u m=1
RT679 vss sub ptap1 A=4e-12 P=8e-6
MM12_56 vb4 vb3 net54 sub sg13_lv_nmos w=1u l=1u m=1
RT680 vss sub ptap1 A=4e-12 P=8e-6
MM12_57 vb4 vb3 net54 sub sg13_lv_nmos w=1u l=1u m=1
RT681 vss sub ptap1 A=4e-12 P=8e-6
MM12_58 vb4 vb3 net54 sub sg13_lv_nmos w=1u l=1u m=1
RT682 vss sub ptap1 A=4e-12 P=8e-6
MM12_59 vb4 vb3 net54 sub sg13_lv_nmos w=1u l=1u m=1
RT683 vss sub ptap1 A=4e-12 P=8e-6
MM12_60 vb4 vb3 net54 sub sg13_lv_nmos w=1u l=1u m=1
RT684 vss sub ptap1 A=4e-12 P=8e-6
MM12_61 vb4 vb3 net54 sub sg13_lv_nmos w=1u l=1u m=1
RT685 vss sub ptap1 A=4e-12 P=8e-6
MM12_62 vb4 vb3 net54 sub sg13_lv_nmos w=1u l=1u m=1
RT686 vss sub ptap1 A=4e-12 P=8e-6
MM12_63 vb4 vb3 net54 sub sg13_lv_nmos w=1u l=1u m=1
RT687 vss sub ptap1 A=4e-12 P=8e-6
MM12_64 vb4 vb3 net54 sub sg13_lv_nmos w=1u l=1u m=1
RT688 vss sub ptap1 A=4e-12 P=8e-6
MM12_65 vb4 vb3 net54 sub sg13_lv_nmos w=1u l=1u m=1
RT689 vss sub ptap1 A=4e-12 P=8e-6
MM12_66 vb4 vb3 net54 sub sg13_lv_nmos w=1u l=1u m=1
RT690 vss sub ptap1 A=4e-12 P=8e-6
MM12_67 vb4 vb3 net54 sub sg13_lv_nmos w=1u l=1u m=1
RT691 vss sub ptap1 A=4e-12 P=8e-6
MM12_68 vb4 vb3 net54 sub sg13_lv_nmos w=1u l=1u m=1
RT692 vss sub ptap1 A=4e-12 P=8e-6
MM12_69 vb4 vb3 net54 sub sg13_lv_nmos w=1u l=1u m=1
RT693 vss sub ptap1 A=4e-12 P=8e-6
MM12_70 vb4 vb3 net54 sub sg13_lv_nmos w=1u l=1u m=1
RT694 vss sub ptap1 A=4e-12 P=8e-6
MM12_71 vb4 vb3 net54 sub sg13_lv_nmos w=1u l=1u m=1
RT695 vss sub ptap1 A=4e-12 P=8e-6
MM12_72 vb4 vb3 net54 sub sg13_lv_nmos w=1u l=1u m=1
RT696 vss sub ptap1 A=4e-12 P=8e-6
MM12_73 vb4 vb3 net54 sub sg13_lv_nmos w=1u l=1u m=1
RT697 vss sub ptap1 A=4e-12 P=8e-6
MM12_74 vb4 vb3 net54 sub sg13_lv_nmos w=1u l=1u m=1
RT698 vss sub ptap1 A=4e-12 P=8e-6
MM12_75 vb4 vb3 net54 sub sg13_lv_nmos w=1u l=1u m=1
RT699 vss sub ptap1 A=4e-12 P=8e-6
MM12_76 vb4 vb3 net54 sub sg13_lv_nmos w=1u l=1u m=1
RT700 vss sub ptap1 A=4e-12 P=8e-6
MM12_77 vb4 vb3 net54 sub sg13_lv_nmos w=1u l=1u m=1
RT701 vss sub ptap1 A=4e-12 P=8e-6
MM12_78 vb4 vb3 net54 sub sg13_lv_nmos w=1u l=1u m=1
RT702 vss sub ptap1 A=4e-12 P=8e-6
MM12_79 vb4 vb3 net54 sub sg13_lv_nmos w=1u l=1u m=1
RT703 vss sub ptap1 A=4e-12 P=8e-6
MM13_0 dm_1 vb3 net56 sub sg13_lv_nmos w=1u l=1u m=1
RT704 vss sub ptap1 A=4e-12 P=8e-6
MM13_1 dm_1 vb3 net56 sub sg13_lv_nmos w=1u l=1u m=1
RT705 vss sub ptap1 A=4e-12 P=8e-6
MM13_2 dm_1 vb3 net56 sub sg13_lv_nmos w=1u l=1u m=1
RT706 vss sub ptap1 A=4e-12 P=8e-6
MM13_3 dm_1 vb3 net56 sub sg13_lv_nmos w=1u l=1u m=1
RT707 vss sub ptap1 A=4e-12 P=8e-6
MM13_4 dm_1 vb3 net56 sub sg13_lv_nmos w=1u l=1u m=1
RT708 vss sub ptap1 A=4e-12 P=8e-6
MM13_5 dm_1 vb3 net56 sub sg13_lv_nmos w=1u l=1u m=1
RT709 vss sub ptap1 A=4e-12 P=8e-6
MM13_6 dm_1 vb3 net56 sub sg13_lv_nmos w=1u l=1u m=1
RT710 vss sub ptap1 A=4e-12 P=8e-6
MM13_7 dm_1 vb3 net56 sub sg13_lv_nmos w=1u l=1u m=1
RT711 vss sub ptap1 A=4e-12 P=8e-6
MM13_8 dm_1 vb3 net56 sub sg13_lv_nmos w=1u l=1u m=1
RT712 vss sub ptap1 A=4e-12 P=8e-6
MM13_9 dm_1 vb3 net56 sub sg13_lv_nmos w=1u l=1u m=1
RT713 vss sub ptap1 A=4e-12 P=8e-6
MM13_10 dm_1 vb3 net56 sub sg13_lv_nmos w=1u l=1u m=1
RT714 vss sub ptap1 A=4e-12 P=8e-6
MM13_11 dm_1 vb3 net56 sub sg13_lv_nmos w=1u l=1u m=1
RT715 vss sub ptap1 A=4e-12 P=8e-6
MM13_12 dm_1 vb3 net56 sub sg13_lv_nmos w=1u l=1u m=1
RT716 vss sub ptap1 A=4e-12 P=8e-6
MM13_13 dm_1 vb3 net56 sub sg13_lv_nmos w=1u l=1u m=1
RT717 vss sub ptap1 A=4e-12 P=8e-6
MM13_14 dm_1 vb3 net56 sub sg13_lv_nmos w=1u l=1u m=1
RT718 vss sub ptap1 A=4e-12 P=8e-6
MM13_15 dm_1 vb3 net56 sub sg13_lv_nmos w=1u l=1u m=1
RT719 vss sub ptap1 A=4e-12 P=8e-6
MM13_16 dm_1 vb3 net56 sub sg13_lv_nmos w=1u l=1u m=1
RT720 vss sub ptap1 A=4e-12 P=8e-6
MM13_17 dm_1 vb3 net56 sub sg13_lv_nmos w=1u l=1u m=1
RT721 vss sub ptap1 A=4e-12 P=8e-6
MM13_18 dm_1 vb3 net56 sub sg13_lv_nmos w=1u l=1u m=1
RT722 vss sub ptap1 A=4e-12 P=8e-6
MM13_19 dm_1 vb3 net56 sub sg13_lv_nmos w=1u l=1u m=1
RT723 vss sub ptap1 A=4e-12 P=8e-6
MM13_20 dm_1 vb3 net56 sub sg13_lv_nmos w=1u l=1u m=1
RT724 vss sub ptap1 A=4e-12 P=8e-6
MM13_21 dm_1 vb3 net56 sub sg13_lv_nmos w=1u l=1u m=1
RT725 vss sub ptap1 A=4e-12 P=8e-6
MM13_22 dm_1 vb3 net56 sub sg13_lv_nmos w=1u l=1u m=1
RT726 vss sub ptap1 A=4e-12 P=8e-6
MM13_23 dm_1 vb3 net56 sub sg13_lv_nmos w=1u l=1u m=1
RT727 vss sub ptap1 A=4e-12 P=8e-6
MM13_24 dm_1 vb3 net56 sub sg13_lv_nmos w=1u l=1u m=1
RT728 vss sub ptap1 A=4e-12 P=8e-6
MM13_25 dm_1 vb3 net56 sub sg13_lv_nmos w=1u l=1u m=1
RT729 vss sub ptap1 A=4e-12 P=8e-6
MM13_26 dm_1 vb3 net56 sub sg13_lv_nmos w=1u l=1u m=1
RT730 vss sub ptap1 A=4e-12 P=8e-6
MM13_27 dm_1 vb3 net56 sub sg13_lv_nmos w=1u l=1u m=1
RT731 vss sub ptap1 A=4e-12 P=8e-6
MM13_28 dm_1 vb3 net56 sub sg13_lv_nmos w=1u l=1u m=1
RT732 vss sub ptap1 A=4e-12 P=8e-6
MM13_29 dm_1 vb3 net56 sub sg13_lv_nmos w=1u l=1u m=1
RT733 vss sub ptap1 A=4e-12 P=8e-6
MM13_30 dm_1 vb3 net56 sub sg13_lv_nmos w=1u l=1u m=1
RT734 vss sub ptap1 A=4e-12 P=8e-6
MM13_31 dm_1 vb3 net56 sub sg13_lv_nmos w=1u l=1u m=1
RT735 vss sub ptap1 A=4e-12 P=8e-6
MM13_32 dm_1 vb3 net56 sub sg13_lv_nmos w=1u l=1u m=1
RT736 vss sub ptap1 A=4e-12 P=8e-6
MM13_33 dm_1 vb3 net56 sub sg13_lv_nmos w=1u l=1u m=1
RT737 vss sub ptap1 A=4e-12 P=8e-6
MM13_34 dm_1 vb3 net56 sub sg13_lv_nmos w=1u l=1u m=1
RT738 vss sub ptap1 A=4e-12 P=8e-6
MM13_35 dm_1 vb3 net56 sub sg13_lv_nmos w=1u l=1u m=1
RT739 vss sub ptap1 A=4e-12 P=8e-6
MM13_36 dm_1 vb3 net56 sub sg13_lv_nmos w=1u l=1u m=1
RT740 vss sub ptap1 A=4e-12 P=8e-6
MM13_37 dm_1 vb3 net56 sub sg13_lv_nmos w=1u l=1u m=1
RT741 vss sub ptap1 A=4e-12 P=8e-6
MM13_38 dm_1 vb3 net56 sub sg13_lv_nmos w=1u l=1u m=1
RT742 vss sub ptap1 A=4e-12 P=8e-6
MM13_39 dm_1 vb3 net56 sub sg13_lv_nmos w=1u l=1u m=1
RT743 vss sub ptap1 A=4e-12 P=8e-6
MM13_40 dm_1 vb3 net56 sub sg13_lv_nmos w=1u l=1u m=1
RT744 vss sub ptap1 A=4e-12 P=8e-6
MM13_41 dm_1 vb3 net56 sub sg13_lv_nmos w=1u l=1u m=1
RT745 vss sub ptap1 A=4e-12 P=8e-6
MM13_42 dm_1 vb3 net56 sub sg13_lv_nmos w=1u l=1u m=1
RT746 vss sub ptap1 A=4e-12 P=8e-6
MM13_43 dm_1 vb3 net56 sub sg13_lv_nmos w=1u l=1u m=1
RT747 vss sub ptap1 A=4e-12 P=8e-6
MM13_44 dm_1 vb3 net56 sub sg13_lv_nmos w=1u l=1u m=1
RT748 vss sub ptap1 A=4e-12 P=8e-6
MM13_45 dm_1 vb3 net56 sub sg13_lv_nmos w=1u l=1u m=1
RT749 vss sub ptap1 A=4e-12 P=8e-6
MM13_46 dm_1 vb3 net56 sub sg13_lv_nmos w=1u l=1u m=1
RT750 vss sub ptap1 A=4e-12 P=8e-6
MM13_47 dm_1 vb3 net56 sub sg13_lv_nmos w=1u l=1u m=1
RT751 vss sub ptap1 A=4e-12 P=8e-6
MM13_48 dm_1 vb3 net56 sub sg13_lv_nmos w=1u l=1u m=1
RT752 vss sub ptap1 A=4e-12 P=8e-6
MM13_49 dm_1 vb3 net56 sub sg13_lv_nmos w=1u l=1u m=1
RT753 vss sub ptap1 A=4e-12 P=8e-6
MM13_50 dm_1 vb3 net56 sub sg13_lv_nmos w=1u l=1u m=1
RT754 vss sub ptap1 A=4e-12 P=8e-6
MM13_51 dm_1 vb3 net56 sub sg13_lv_nmos w=1u l=1u m=1
RT755 vss sub ptap1 A=4e-12 P=8e-6
MM13_52 dm_1 vb3 net56 sub sg13_lv_nmos w=1u l=1u m=1
RT756 vss sub ptap1 A=4e-12 P=8e-6
MM13_53 dm_1 vb3 net56 sub sg13_lv_nmos w=1u l=1u m=1
RT757 vss sub ptap1 A=4e-12 P=8e-6
MM13_54 dm_1 vb3 net56 sub sg13_lv_nmos w=1u l=1u m=1
RT758 vss sub ptap1 A=4e-12 P=8e-6
MM13_55 dm_1 vb3 net56 sub sg13_lv_nmos w=1u l=1u m=1
RT759 vss sub ptap1 A=4e-12 P=8e-6
MM13_56 dm_1 vb3 net56 sub sg13_lv_nmos w=1u l=1u m=1
RT760 vss sub ptap1 A=4e-12 P=8e-6
MM13_57 dm_1 vb3 net56 sub sg13_lv_nmos w=1u l=1u m=1
RT761 vss sub ptap1 A=4e-12 P=8e-6
MM13_58 dm_1 vb3 net56 sub sg13_lv_nmos w=1u l=1u m=1
RT762 vss sub ptap1 A=4e-12 P=8e-6
MM13_59 dm_1 vb3 net56 sub sg13_lv_nmos w=1u l=1u m=1
RT763 vss sub ptap1 A=4e-12 P=8e-6
MM13_60 dm_1 vb3 net56 sub sg13_lv_nmos w=1u l=1u m=1
RT764 vss sub ptap1 A=4e-12 P=8e-6
MM13_61 dm_1 vb3 net56 sub sg13_lv_nmos w=1u l=1u m=1
RT765 vss sub ptap1 A=4e-12 P=8e-6
MM13_62 dm_1 vb3 net56 sub sg13_lv_nmos w=1u l=1u m=1
RT766 vss sub ptap1 A=4e-12 P=8e-6
MM13_63 dm_1 vb3 net56 sub sg13_lv_nmos w=1u l=1u m=1
RT767 vss sub ptap1 A=4e-12 P=8e-6
MM13_64 dm_1 vb3 net56 sub sg13_lv_nmos w=1u l=1u m=1
RT768 vss sub ptap1 A=4e-12 P=8e-6
MM13_65 dm_1 vb3 net56 sub sg13_lv_nmos w=1u l=1u m=1
RT769 vss sub ptap1 A=4e-12 P=8e-6
MM13_66 dm_1 vb3 net56 sub sg13_lv_nmos w=1u l=1u m=1
RT770 vss sub ptap1 A=4e-12 P=8e-6
MM13_67 dm_1 vb3 net56 sub sg13_lv_nmos w=1u l=1u m=1
RT771 vss sub ptap1 A=4e-12 P=8e-6
MM13_68 dm_1 vb3 net56 sub sg13_lv_nmos w=1u l=1u m=1
RT772 vss sub ptap1 A=4e-12 P=8e-6
MM13_69 dm_1 vb3 net56 sub sg13_lv_nmos w=1u l=1u m=1
RT773 vss sub ptap1 A=4e-12 P=8e-6
MM13_70 dm_1 vb3 net56 sub sg13_lv_nmos w=1u l=1u m=1
RT774 vss sub ptap1 A=4e-12 P=8e-6
MM13_71 dm_1 vb3 net56 sub sg13_lv_nmos w=1u l=1u m=1
RT775 vss sub ptap1 A=4e-12 P=8e-6
MM13_72 dm_1 vb3 net56 sub sg13_lv_nmos w=1u l=1u m=1
RT776 vss sub ptap1 A=4e-12 P=8e-6
MM13_73 dm_1 vb3 net56 sub sg13_lv_nmos w=1u l=1u m=1
RT777 vss sub ptap1 A=4e-12 P=8e-6
MM13_74 dm_1 vb3 net56 sub sg13_lv_nmos w=1u l=1u m=1
RT778 vss sub ptap1 A=4e-12 P=8e-6
MM13_75 dm_1 vb3 net56 sub sg13_lv_nmos w=1u l=1u m=1
RT779 vss sub ptap1 A=4e-12 P=8e-6
MM13_76 dm_1 vb3 net56 sub sg13_lv_nmos w=1u l=1u m=1
RT780 vss sub ptap1 A=4e-12 P=8e-6
MM13_77 dm_1 vb3 net56 sub sg13_lv_nmos w=1u l=1u m=1
RT781 vss sub ptap1 A=4e-12 P=8e-6
MM13_78 dm_1 vb3 net56 sub sg13_lv_nmos w=1u l=1u m=1
RT782 vss sub ptap1 A=4e-12 P=8e-6
MM13_79 dm_1 vb3 net56 sub sg13_lv_nmos w=1u l=1u m=1
RT783 vss sub ptap1 A=4e-12 P=8e-6
MM14_0 vb3 vb3 vss sub sg13_lv_nmos w=1u l=1u m=1
RT784 vss sub ptap1 A=4e-12 P=8e-6
MM14_1 vb3 vb3 vss sub sg13_lv_nmos w=1u l=1u m=1
RT785 vss sub ptap1 A=4e-12 P=8e-6
MM14_2 vb3 vb3 vss sub sg13_lv_nmos w=1u l=1u m=1
RT786 vss sub ptap1 A=4e-12 P=8e-6
MM14_3 vb3 vb3 vss sub sg13_lv_nmos w=1u l=1u m=1
RT787 vss sub ptap1 A=4e-12 P=8e-6
MM14_4 vb3 vb3 vss sub sg13_lv_nmos w=1u l=1u m=1
RT788 vss sub ptap1 A=4e-12 P=8e-6
MM14_5 vb3 vb3 vss sub sg13_lv_nmos w=1u l=1u m=1
RT789 vss sub ptap1 A=4e-12 P=8e-6
MM14_6 vb3 vb3 vss sub sg13_lv_nmos w=1u l=1u m=1
RT790 vss sub ptap1 A=4e-12 P=8e-6
MM14_7 vb3 vb3 vss sub sg13_lv_nmos w=1u l=1u m=1
RT791 vss sub ptap1 A=4e-12 P=8e-6
MM14_8 vb3 vb3 vss sub sg13_lv_nmos w=1u l=1u m=1
RT792 vss sub ptap1 A=4e-12 P=8e-6
MM14_9 vb3 vb3 vss sub sg13_lv_nmos w=1u l=1u m=1
RT793 vss sub ptap1 A=4e-12 P=8e-6
MM14_10 vb3 vb3 vss sub sg13_lv_nmos w=1u l=1u m=1
RT794 vss sub ptap1 A=4e-12 P=8e-6
MM14_11 vb3 vb3 vss sub sg13_lv_nmos w=1u l=1u m=1
RT795 vss sub ptap1 A=4e-12 P=8e-6
MM14_12 vb3 vb3 vss sub sg13_lv_nmos w=1u l=1u m=1
RT796 vss sub ptap1 A=4e-12 P=8e-6
MM14_13 vb3 vb3 vss sub sg13_lv_nmos w=1u l=1u m=1
RT797 vss sub ptap1 A=4e-12 P=8e-6
MM14_14 vb3 vb3 vss sub sg13_lv_nmos w=1u l=1u m=1
RT798 vss sub ptap1 A=4e-12 P=8e-6
MM14_15 vb3 vb3 vss sub sg13_lv_nmos w=1u l=1u m=1
RT799 vss sub ptap1 A=4e-12 P=8e-6
MM14_16 vb3 vb3 vss sub sg13_lv_nmos w=1u l=1u m=1
RT800 vss sub ptap1 A=4e-12 P=8e-6
MM14_17 vb3 vb3 vss sub sg13_lv_nmos w=1u l=1u m=1
RT801 vss sub ptap1 A=4e-12 P=8e-6
MM14_18 vb3 vb3 vss sub sg13_lv_nmos w=1u l=1u m=1
RT802 vss sub ptap1 A=4e-12 P=8e-6
MM14_19 vb3 vb3 vss sub sg13_lv_nmos w=1u l=1u m=1
RT803 vss sub ptap1 A=4e-12 P=8e-6
MM15_0 voutn vb3 dm_2 sub sg13_lv_nmos w=1u l=1u m=1
RT804 vss sub ptap1 A=4e-12 P=8e-6
MM15_1 voutn vb3 dm_2 sub sg13_lv_nmos w=1u l=1u m=1
RT805 vss sub ptap1 A=4e-12 P=8e-6
MM15_2 voutn vb3 dm_2 sub sg13_lv_nmos w=1u l=1u m=1
RT806 vss sub ptap1 A=4e-12 P=8e-6
MM15_3 voutn vb3 dm_2 sub sg13_lv_nmos w=1u l=1u m=1
RT807 vss sub ptap1 A=4e-12 P=8e-6
MM15_4 voutn vb3 dm_2 sub sg13_lv_nmos w=1u l=1u m=1
RT808 vss sub ptap1 A=4e-12 P=8e-6
MM15_5 voutn vb3 dm_2 sub sg13_lv_nmos w=1u l=1u m=1
RT809 vss sub ptap1 A=4e-12 P=8e-6
MM15_6 voutn vb3 dm_2 sub sg13_lv_nmos w=1u l=1u m=1
RT810 vss sub ptap1 A=4e-12 P=8e-6
MM15_7 voutn vb3 dm_2 sub sg13_lv_nmos w=1u l=1u m=1
RT811 vss sub ptap1 A=4e-12 P=8e-6
MM15_8 voutn vb3 dm_2 sub sg13_lv_nmos w=1u l=1u m=1
RT812 vss sub ptap1 A=4e-12 P=8e-6
MM15_9 voutn vb3 dm_2 sub sg13_lv_nmos w=1u l=1u m=1
RT813 vss sub ptap1 A=4e-12 P=8e-6
MM15_10 voutn vb3 dm_2 sub sg13_lv_nmos w=1u l=1u m=1
RT814 vss sub ptap1 A=4e-12 P=8e-6
MM15_11 voutn vb3 dm_2 sub sg13_lv_nmos w=1u l=1u m=1
RT815 vss sub ptap1 A=4e-12 P=8e-6
MM15_12 voutn vb3 dm_2 sub sg13_lv_nmos w=1u l=1u m=1
RT816 vss sub ptap1 A=4e-12 P=8e-6
MM15_13 voutn vb3 dm_2 sub sg13_lv_nmos w=1u l=1u m=1
RT817 vss sub ptap1 A=4e-12 P=8e-6
MM15_14 voutn vb3 dm_2 sub sg13_lv_nmos w=1u l=1u m=1
RT818 vss sub ptap1 A=4e-12 P=8e-6
MM15_15 voutn vb3 dm_2 sub sg13_lv_nmos w=1u l=1u m=1
RT819 vss sub ptap1 A=4e-12 P=8e-6
MM15_16 voutn vb3 dm_2 sub sg13_lv_nmos w=1u l=1u m=1
RT820 vss sub ptap1 A=4e-12 P=8e-6
MM15_17 voutn vb3 dm_2 sub sg13_lv_nmos w=1u l=1u m=1
RT821 vss sub ptap1 A=4e-12 P=8e-6
MM15_18 voutn vb3 dm_2 sub sg13_lv_nmos w=1u l=1u m=1
RT822 vss sub ptap1 A=4e-12 P=8e-6
MM15_19 voutn vb3 dm_2 sub sg13_lv_nmos w=1u l=1u m=1
RT823 vss sub ptap1 A=4e-12 P=8e-6
MM15_20 voutn vb3 dm_2 sub sg13_lv_nmos w=1u l=1u m=1
RT824 vss sub ptap1 A=4e-12 P=8e-6
MM15_21 voutn vb3 dm_2 sub sg13_lv_nmos w=1u l=1u m=1
RT825 vss sub ptap1 A=4e-12 P=8e-6
MM15_22 voutn vb3 dm_2 sub sg13_lv_nmos w=1u l=1u m=1
RT826 vss sub ptap1 A=4e-12 P=8e-6
MM15_23 voutn vb3 dm_2 sub sg13_lv_nmos w=1u l=1u m=1
RT827 vss sub ptap1 A=4e-12 P=8e-6
MM15_24 voutn vb3 dm_2 sub sg13_lv_nmos w=1u l=1u m=1
RT828 vss sub ptap1 A=4e-12 P=8e-6
MM15_25 voutn vb3 dm_2 sub sg13_lv_nmos w=1u l=1u m=1
RT829 vss sub ptap1 A=4e-12 P=8e-6
MM15_26 voutn vb3 dm_2 sub sg13_lv_nmos w=1u l=1u m=1
RT830 vss sub ptap1 A=4e-12 P=8e-6
MM15_27 voutn vb3 dm_2 sub sg13_lv_nmos w=1u l=1u m=1
RT831 vss sub ptap1 A=4e-12 P=8e-6
MM15_28 voutn vb3 dm_2 sub sg13_lv_nmos w=1u l=1u m=1
RT832 vss sub ptap1 A=4e-12 P=8e-6
MM15_29 voutn vb3 dm_2 sub sg13_lv_nmos w=1u l=1u m=1
RT833 vss sub ptap1 A=4e-12 P=8e-6
MM15_30 voutn vb3 dm_2 sub sg13_lv_nmos w=1u l=1u m=1
RT834 vss sub ptap1 A=4e-12 P=8e-6
MM15_31 voutn vb3 dm_2 sub sg13_lv_nmos w=1u l=1u m=1
RT835 vss sub ptap1 A=4e-12 P=8e-6
MM15_32 voutn vb3 dm_2 sub sg13_lv_nmos w=1u l=1u m=1
RT836 vss sub ptap1 A=4e-12 P=8e-6
MM15_33 voutn vb3 dm_2 sub sg13_lv_nmos w=1u l=1u m=1
RT837 vss sub ptap1 A=4e-12 P=8e-6
MM15_34 voutn vb3 dm_2 sub sg13_lv_nmos w=1u l=1u m=1
RT838 vss sub ptap1 A=4e-12 P=8e-6
MM15_35 voutn vb3 dm_2 sub sg13_lv_nmos w=1u l=1u m=1
RT839 vss sub ptap1 A=4e-12 P=8e-6
MM15_36 voutn vb3 dm_2 sub sg13_lv_nmos w=1u l=1u m=1
RT840 vss sub ptap1 A=4e-12 P=8e-6
MM15_37 voutn vb3 dm_2 sub sg13_lv_nmos w=1u l=1u m=1
RT841 vss sub ptap1 A=4e-12 P=8e-6
MM15_38 voutn vb3 dm_2 sub sg13_lv_nmos w=1u l=1u m=1
RT842 vss sub ptap1 A=4e-12 P=8e-6
MM15_39 voutn vb3 dm_2 sub sg13_lv_nmos w=1u l=1u m=1
RT843 vss sub ptap1 A=4e-12 P=8e-6
MM15_40 voutn vb3 dm_2 sub sg13_lv_nmos w=1u l=1u m=1
RT844 vss sub ptap1 A=4e-12 P=8e-6
MM15_41 voutn vb3 dm_2 sub sg13_lv_nmos w=1u l=1u m=1
RT845 vss sub ptap1 A=4e-12 P=8e-6
MM15_42 voutn vb3 dm_2 sub sg13_lv_nmos w=1u l=1u m=1
RT846 vss sub ptap1 A=4e-12 P=8e-6
MM15_43 voutn vb3 dm_2 sub sg13_lv_nmos w=1u l=1u m=1
RT847 vss sub ptap1 A=4e-12 P=8e-6
MM15_44 voutn vb3 dm_2 sub sg13_lv_nmos w=1u l=1u m=1
RT848 vss sub ptap1 A=4e-12 P=8e-6
MM15_45 voutn vb3 dm_2 sub sg13_lv_nmos w=1u l=1u m=1
RT849 vss sub ptap1 A=4e-12 P=8e-6
MM15_46 voutn vb3 dm_2 sub sg13_lv_nmos w=1u l=1u m=1
RT850 vss sub ptap1 A=4e-12 P=8e-6
MM15_47 voutn vb3 dm_2 sub sg13_lv_nmos w=1u l=1u m=1
RT851 vss sub ptap1 A=4e-12 P=8e-6
MM15_48 voutn vb3 dm_2 sub sg13_lv_nmos w=1u l=1u m=1
RT852 vss sub ptap1 A=4e-12 P=8e-6
MM15_49 voutn vb3 dm_2 sub sg13_lv_nmos w=1u l=1u m=1
RT853 vss sub ptap1 A=4e-12 P=8e-6
MM15_50 voutn vb3 dm_2 sub sg13_lv_nmos w=1u l=1u m=1
RT854 vss sub ptap1 A=4e-12 P=8e-6
MM15_51 voutn vb3 dm_2 sub sg13_lv_nmos w=1u l=1u m=1
RT855 vss sub ptap1 A=4e-12 P=8e-6
MM15_52 voutn vb3 dm_2 sub sg13_lv_nmos w=1u l=1u m=1
RT856 vss sub ptap1 A=4e-12 P=8e-6
MM15_53 voutn vb3 dm_2 sub sg13_lv_nmos w=1u l=1u m=1
RT857 vss sub ptap1 A=4e-12 P=8e-6
MM15_54 voutn vb3 dm_2 sub sg13_lv_nmos w=1u l=1u m=1
RT858 vss sub ptap1 A=4e-12 P=8e-6
MM15_55 voutn vb3 dm_2 sub sg13_lv_nmos w=1u l=1u m=1
RT859 vss sub ptap1 A=4e-12 P=8e-6
MM15_56 voutn vb3 dm_2 sub sg13_lv_nmos w=1u l=1u m=1
RT860 vss sub ptap1 A=4e-12 P=8e-6
MM15_57 voutn vb3 dm_2 sub sg13_lv_nmos w=1u l=1u m=1
RT861 vss sub ptap1 A=4e-12 P=8e-6
MM15_58 voutn vb3 dm_2 sub sg13_lv_nmos w=1u l=1u m=1
RT862 vss sub ptap1 A=4e-12 P=8e-6
MM15_59 voutn vb3 dm_2 sub sg13_lv_nmos w=1u l=1u m=1
RT863 vss sub ptap1 A=4e-12 P=8e-6
MM15_60 voutn vb3 dm_2 sub sg13_lv_nmos w=1u l=1u m=1
RT864 vss sub ptap1 A=4e-12 P=8e-6
MM15_61 voutn vb3 dm_2 sub sg13_lv_nmos w=1u l=1u m=1
RT865 vss sub ptap1 A=4e-12 P=8e-6
MM15_62 voutn vb3 dm_2 sub sg13_lv_nmos w=1u l=1u m=1
RT866 vss sub ptap1 A=4e-12 P=8e-6
MM15_63 voutn vb3 dm_2 sub sg13_lv_nmos w=1u l=1u m=1
RT867 vss sub ptap1 A=4e-12 P=8e-6
MM15_64 voutn vb3 dm_2 sub sg13_lv_nmos w=1u l=1u m=1
RT868 vss sub ptap1 A=4e-12 P=8e-6
MM15_65 voutn vb3 dm_2 sub sg13_lv_nmos w=1u l=1u m=1
RT869 vss sub ptap1 A=4e-12 P=8e-6
MM15_66 voutn vb3 dm_2 sub sg13_lv_nmos w=1u l=1u m=1
RT870 vss sub ptap1 A=4e-12 P=8e-6
MM15_67 voutn vb3 dm_2 sub sg13_lv_nmos w=1u l=1u m=1
RT871 vss sub ptap1 A=4e-12 P=8e-6
MM15_68 voutn vb3 dm_2 sub sg13_lv_nmos w=1u l=1u m=1
RT872 vss sub ptap1 A=4e-12 P=8e-6
MM15_69 voutn vb3 dm_2 sub sg13_lv_nmos w=1u l=1u m=1
RT873 vss sub ptap1 A=4e-12 P=8e-6
MM15_70 voutn vb3 dm_2 sub sg13_lv_nmos w=1u l=1u m=1
RT874 vss sub ptap1 A=4e-12 P=8e-6
MM15_71 voutn vb3 dm_2 sub sg13_lv_nmos w=1u l=1u m=1
RT875 vss sub ptap1 A=4e-12 P=8e-6
MM15_72 voutn vb3 dm_2 sub sg13_lv_nmos w=1u l=1u m=1
RT876 vss sub ptap1 A=4e-12 P=8e-6
MM15_73 voutn vb3 dm_2 sub sg13_lv_nmos w=1u l=1u m=1
RT877 vss sub ptap1 A=4e-12 P=8e-6
MM15_74 voutn vb3 dm_2 sub sg13_lv_nmos w=1u l=1u m=1
RT878 vss sub ptap1 A=4e-12 P=8e-6
MM15_75 voutn vb3 dm_2 sub sg13_lv_nmos w=1u l=1u m=1
RT879 vss sub ptap1 A=4e-12 P=8e-6
MM15_76 voutn vb3 dm_2 sub sg13_lv_nmos w=1u l=1u m=1
RT880 vss sub ptap1 A=4e-12 P=8e-6
MM15_77 voutn vb3 dm_2 sub sg13_lv_nmos w=1u l=1u m=1
RT881 vss sub ptap1 A=4e-12 P=8e-6
MM15_78 voutn vb3 dm_2 sub sg13_lv_nmos w=1u l=1u m=1
RT882 vss sub ptap1 A=4e-12 P=8e-6
MM15_79 voutn vb3 dm_2 sub sg13_lv_nmos w=1u l=1u m=1
RT883 vss sub ptap1 A=4e-12 P=8e-6
MM16_0 net050 vb3 net063 sub sg13_lv_nmos w=1u l=1u m=1
RT884 vss sub ptap1 A=4e-12 P=8e-6
MM16_1 net050 vb3 net063 sub sg13_lv_nmos w=1u l=1u m=1
RT885 vss sub ptap1 A=4e-12 P=8e-6
MM16_2 net050 vb3 net063 sub sg13_lv_nmos w=1u l=1u m=1
RT886 vss sub ptap1 A=4e-12 P=8e-6
MM16_3 net050 vb3 net063 sub sg13_lv_nmos w=1u l=1u m=1
RT887 vss sub ptap1 A=4e-12 P=8e-6
MM16_4 net050 vb3 net063 sub sg13_lv_nmos w=1u l=1u m=1
RT888 vss sub ptap1 A=4e-12 P=8e-6
MM16_5 net050 vb3 net063 sub sg13_lv_nmos w=1u l=1u m=1
RT889 vss sub ptap1 A=4e-12 P=8e-6
MM16_6 net050 vb3 net063 sub sg13_lv_nmos w=1u l=1u m=1
RT890 vss sub ptap1 A=4e-12 P=8e-6
MM16_7 net050 vb3 net063 sub sg13_lv_nmos w=1u l=1u m=1
RT891 vss sub ptap1 A=4e-12 P=8e-6
MM16_8 net050 vb3 net063 sub sg13_lv_nmos w=1u l=1u m=1
RT892 vss sub ptap1 A=4e-12 P=8e-6
MM16_9 net050 vb3 net063 sub sg13_lv_nmos w=1u l=1u m=1
RT893 vss sub ptap1 A=4e-12 P=8e-6
MM16_10 net050 vb3 net063 sub sg13_lv_nmos w=1u l=1u m=1
RT894 vss sub ptap1 A=4e-12 P=8e-6
MM16_11 net050 vb3 net063 sub sg13_lv_nmos w=1u l=1u m=1
RT895 vss sub ptap1 A=4e-12 P=8e-6
MM16_12 net050 vb3 net063 sub sg13_lv_nmos w=1u l=1u m=1
RT896 vss sub ptap1 A=4e-12 P=8e-6
MM16_13 net050 vb3 net063 sub sg13_lv_nmos w=1u l=1u m=1
RT897 vss sub ptap1 A=4e-12 P=8e-6
MM16_14 net050 vb3 net063 sub sg13_lv_nmos w=1u l=1u m=1
RT898 vss sub ptap1 A=4e-12 P=8e-6
MM16_15 net050 vb3 net063 sub sg13_lv_nmos w=1u l=1u m=1
RT899 vss sub ptap1 A=4e-12 P=8e-6
MM16_16 net050 vb3 net063 sub sg13_lv_nmos w=1u l=1u m=1
RT900 vss sub ptap1 A=4e-12 P=8e-6
MM16_17 net050 vb3 net063 sub sg13_lv_nmos w=1u l=1u m=1
RT901 vss sub ptap1 A=4e-12 P=8e-6
MM16_18 net050 vb3 net063 sub sg13_lv_nmos w=1u l=1u m=1
RT902 vss sub ptap1 A=4e-12 P=8e-6
MM16_19 net050 vb3 net063 sub sg13_lv_nmos w=1u l=1u m=1
RT903 vss sub ptap1 A=4e-12 P=8e-6
MM16_20 net050 vb3 net063 sub sg13_lv_nmos w=1u l=1u m=1
RT904 vss sub ptap1 A=4e-12 P=8e-6
MM16_21 net050 vb3 net063 sub sg13_lv_nmos w=1u l=1u m=1
RT905 vss sub ptap1 A=4e-12 P=8e-6
MM16_22 net050 vb3 net063 sub sg13_lv_nmos w=1u l=1u m=1
RT906 vss sub ptap1 A=4e-12 P=8e-6
MM16_23 net050 vb3 net063 sub sg13_lv_nmos w=1u l=1u m=1
RT907 vss sub ptap1 A=4e-12 P=8e-6
MM16_24 net050 vb3 net063 sub sg13_lv_nmos w=1u l=1u m=1
RT908 vss sub ptap1 A=4e-12 P=8e-6
MM16_25 net050 vb3 net063 sub sg13_lv_nmos w=1u l=1u m=1
RT909 vss sub ptap1 A=4e-12 P=8e-6
MM16_26 net050 vb3 net063 sub sg13_lv_nmos w=1u l=1u m=1
RT910 vss sub ptap1 A=4e-12 P=8e-6
MM16_27 net050 vb3 net063 sub sg13_lv_nmos w=1u l=1u m=1
RT911 vss sub ptap1 A=4e-12 P=8e-6
MM16_28 net050 vb3 net063 sub sg13_lv_nmos w=1u l=1u m=1
RT912 vss sub ptap1 A=4e-12 P=8e-6
MM16_29 net050 vb3 net063 sub sg13_lv_nmos w=1u l=1u m=1
RT913 vss sub ptap1 A=4e-12 P=8e-6
MM16_30 net050 vb3 net063 sub sg13_lv_nmos w=1u l=1u m=1
RT914 vss sub ptap1 A=4e-12 P=8e-6
MM16_31 net050 vb3 net063 sub sg13_lv_nmos w=1u l=1u m=1
RT915 vss sub ptap1 A=4e-12 P=8e-6
MM16_32 net050 vb3 net063 sub sg13_lv_nmos w=1u l=1u m=1
RT916 vss sub ptap1 A=4e-12 P=8e-6
MM16_33 net050 vb3 net063 sub sg13_lv_nmos w=1u l=1u m=1
RT917 vss sub ptap1 A=4e-12 P=8e-6
MM16_34 net050 vb3 net063 sub sg13_lv_nmos w=1u l=1u m=1
RT918 vss sub ptap1 A=4e-12 P=8e-6
MM16_35 net050 vb3 net063 sub sg13_lv_nmos w=1u l=1u m=1
RT919 vss sub ptap1 A=4e-12 P=8e-6
MM16_36 net050 vb3 net063 sub sg13_lv_nmos w=1u l=1u m=1
RT920 vss sub ptap1 A=4e-12 P=8e-6
MM16_37 net050 vb3 net063 sub sg13_lv_nmos w=1u l=1u m=1
RT921 vss sub ptap1 A=4e-12 P=8e-6
MM16_38 net050 vb3 net063 sub sg13_lv_nmos w=1u l=1u m=1
RT922 vss sub ptap1 A=4e-12 P=8e-6
MM16_39 net050 vb3 net063 sub sg13_lv_nmos w=1u l=1u m=1
RT923 vss sub ptap1 A=4e-12 P=8e-6
MM16_40 net050 vb3 net063 sub sg13_lv_nmos w=1u l=1u m=1
RT924 vss sub ptap1 A=4e-12 P=8e-6
MM16_41 net050 vb3 net063 sub sg13_lv_nmos w=1u l=1u m=1
RT925 vss sub ptap1 A=4e-12 P=8e-6
MM16_42 net050 vb3 net063 sub sg13_lv_nmos w=1u l=1u m=1
RT926 vss sub ptap1 A=4e-12 P=8e-6
MM16_43 net050 vb3 net063 sub sg13_lv_nmos w=1u l=1u m=1
RT927 vss sub ptap1 A=4e-12 P=8e-6
MM16_44 net050 vb3 net063 sub sg13_lv_nmos w=1u l=1u m=1
RT928 vss sub ptap1 A=4e-12 P=8e-6
MM16_45 net050 vb3 net063 sub sg13_lv_nmos w=1u l=1u m=1
RT929 vss sub ptap1 A=4e-12 P=8e-6
MM16_46 net050 vb3 net063 sub sg13_lv_nmos w=1u l=1u m=1
RT930 vss sub ptap1 A=4e-12 P=8e-6
MM16_47 net050 vb3 net063 sub sg13_lv_nmos w=1u l=1u m=1
RT931 vss sub ptap1 A=4e-12 P=8e-6
MM16_48 net050 vb3 net063 sub sg13_lv_nmos w=1u l=1u m=1
RT932 vss sub ptap1 A=4e-12 P=8e-6
MM16_49 net050 vb3 net063 sub sg13_lv_nmos w=1u l=1u m=1
RT933 vss sub ptap1 A=4e-12 P=8e-6
MM16_50 net050 vb3 net063 sub sg13_lv_nmos w=1u l=1u m=1
RT934 vss sub ptap1 A=4e-12 P=8e-6
MM16_51 net050 vb3 net063 sub sg13_lv_nmos w=1u l=1u m=1
RT935 vss sub ptap1 A=4e-12 P=8e-6
MM16_52 net050 vb3 net063 sub sg13_lv_nmos w=1u l=1u m=1
RT936 vss sub ptap1 A=4e-12 P=8e-6
MM16_53 net050 vb3 net063 sub sg13_lv_nmos w=1u l=1u m=1
RT937 vss sub ptap1 A=4e-12 P=8e-6
MM16_54 net050 vb3 net063 sub sg13_lv_nmos w=1u l=1u m=1
RT938 vss sub ptap1 A=4e-12 P=8e-6
MM16_55 net050 vb3 net063 sub sg13_lv_nmos w=1u l=1u m=1
RT939 vss sub ptap1 A=4e-12 P=8e-6
MM16_56 net050 vb3 net063 sub sg13_lv_nmos w=1u l=1u m=1
RT940 vss sub ptap1 A=4e-12 P=8e-6
MM16_57 net050 vb3 net063 sub sg13_lv_nmos w=1u l=1u m=1
RT941 vss sub ptap1 A=4e-12 P=8e-6
MM16_58 net050 vb3 net063 sub sg13_lv_nmos w=1u l=1u m=1
RT942 vss sub ptap1 A=4e-12 P=8e-6
MM16_59 net050 vb3 net063 sub sg13_lv_nmos w=1u l=1u m=1
RT943 vss sub ptap1 A=4e-12 P=8e-6
MM16_60 net050 vb3 net063 sub sg13_lv_nmos w=1u l=1u m=1
RT944 vss sub ptap1 A=4e-12 P=8e-6
MM16_61 net050 vb3 net063 sub sg13_lv_nmos w=1u l=1u m=1
RT945 vss sub ptap1 A=4e-12 P=8e-6
MM16_62 net050 vb3 net063 sub sg13_lv_nmos w=1u l=1u m=1
RT946 vss sub ptap1 A=4e-12 P=8e-6
MM16_63 net050 vb3 net063 sub sg13_lv_nmos w=1u l=1u m=1
RT947 vss sub ptap1 A=4e-12 P=8e-6
MM16_64 net050 vb3 net063 sub sg13_lv_nmos w=1u l=1u m=1
RT948 vss sub ptap1 A=4e-12 P=8e-6
MM16_65 net050 vb3 net063 sub sg13_lv_nmos w=1u l=1u m=1
RT949 vss sub ptap1 A=4e-12 P=8e-6
MM16_66 net050 vb3 net063 sub sg13_lv_nmos w=1u l=1u m=1
RT950 vss sub ptap1 A=4e-12 P=8e-6
MM16_67 net050 vb3 net063 sub sg13_lv_nmos w=1u l=1u m=1
RT951 vss sub ptap1 A=4e-12 P=8e-6
MM16_68 net050 vb3 net063 sub sg13_lv_nmos w=1u l=1u m=1
RT952 vss sub ptap1 A=4e-12 P=8e-6
MM16_69 net050 vb3 net063 sub sg13_lv_nmos w=1u l=1u m=1
RT953 vss sub ptap1 A=4e-12 P=8e-6
MM16_70 net050 vb3 net063 sub sg13_lv_nmos w=1u l=1u m=1
RT954 vss sub ptap1 A=4e-12 P=8e-6
MM16_71 net050 vb3 net063 sub sg13_lv_nmos w=1u l=1u m=1
RT955 vss sub ptap1 A=4e-12 P=8e-6
MM16_72 net050 vb3 net063 sub sg13_lv_nmos w=1u l=1u m=1
RT956 vss sub ptap1 A=4e-12 P=8e-6
MM16_73 net050 vb3 net063 sub sg13_lv_nmos w=1u l=1u m=1
RT957 vss sub ptap1 A=4e-12 P=8e-6
MM16_74 net050 vb3 net063 sub sg13_lv_nmos w=1u l=1u m=1
RT958 vss sub ptap1 A=4e-12 P=8e-6
MM16_75 net050 vb3 net063 sub sg13_lv_nmos w=1u l=1u m=1
RT959 vss sub ptap1 A=4e-12 P=8e-6
MM16_76 net050 vb3 net063 sub sg13_lv_nmos w=1u l=1u m=1
RT960 vss sub ptap1 A=4e-12 P=8e-6
MM16_77 net050 vb3 net063 sub sg13_lv_nmos w=1u l=1u m=1
RT961 vss sub ptap1 A=4e-12 P=8e-6
MM16_78 net050 vb3 net063 sub sg13_lv_nmos w=1u l=1u m=1
RT962 vss sub ptap1 A=4e-12 P=8e-6
MM16_79 net050 vb3 net063 sub sg13_lv_nmos w=1u l=1u m=1
RT963 vss sub ptap1 A=4e-12 P=8e-6
MM17_0 net54 vb4 vss sub sg13_lv_nmos w=1u l=1u m=1
RT964 vss sub ptap1 A=4e-12 P=8e-6
MM17_1 net54 vb4 vss sub sg13_lv_nmos w=1u l=1u m=1
RT965 vss sub ptap1 A=4e-12 P=8e-6
MM17_2 net54 vb4 vss sub sg13_lv_nmos w=1u l=1u m=1
RT966 vss sub ptap1 A=4e-12 P=8e-6
MM17_3 net54 vb4 vss sub sg13_lv_nmos w=1u l=1u m=1
RT967 vss sub ptap1 A=4e-12 P=8e-6
MM17_4 net54 vb4 vss sub sg13_lv_nmos w=1u l=1u m=1
RT968 vss sub ptap1 A=4e-12 P=8e-6
MM17_5 net54 vb4 vss sub sg13_lv_nmos w=1u l=1u m=1
RT969 vss sub ptap1 A=4e-12 P=8e-6
MM17_6 net54 vb4 vss sub sg13_lv_nmos w=1u l=1u m=1
RT970 vss sub ptap1 A=4e-12 P=8e-6
MM17_7 net54 vb4 vss sub sg13_lv_nmos w=1u l=1u m=1
RT971 vss sub ptap1 A=4e-12 P=8e-6
MM17_8 net54 vb4 vss sub sg13_lv_nmos w=1u l=1u m=1
RT972 vss sub ptap1 A=4e-12 P=8e-6
MM17_9 net54 vb4 vss sub sg13_lv_nmos w=1u l=1u m=1
RT973 vss sub ptap1 A=4e-12 P=8e-6
MM17_10 net54 vb4 vss sub sg13_lv_nmos w=1u l=1u m=1
RT974 vss sub ptap1 A=4e-12 P=8e-6
MM17_11 net54 vb4 vss sub sg13_lv_nmos w=1u l=1u m=1
RT975 vss sub ptap1 A=4e-12 P=8e-6
MM17_12 net54 vb4 vss sub sg13_lv_nmos w=1u l=1u m=1
RT976 vss sub ptap1 A=4e-12 P=8e-6
MM17_13 net54 vb4 vss sub sg13_lv_nmos w=1u l=1u m=1
RT977 vss sub ptap1 A=4e-12 P=8e-6
MM17_14 net54 vb4 vss sub sg13_lv_nmos w=1u l=1u m=1
RT978 vss sub ptap1 A=4e-12 P=8e-6
MM17_15 net54 vb4 vss sub sg13_lv_nmos w=1u l=1u m=1
RT979 vss sub ptap1 A=4e-12 P=8e-6
MM17_16 net54 vb4 vss sub sg13_lv_nmos w=1u l=1u m=1
RT980 vss sub ptap1 A=4e-12 P=8e-6
MM17_17 net54 vb4 vss sub sg13_lv_nmos w=1u l=1u m=1
RT981 vss sub ptap1 A=4e-12 P=8e-6
MM17_18 net54 vb4 vss sub sg13_lv_nmos w=1u l=1u m=1
RT982 vss sub ptap1 A=4e-12 P=8e-6
MM17_19 net54 vb4 vss sub sg13_lv_nmos w=1u l=1u m=1
RT983 vss sub ptap1 A=4e-12 P=8e-6
MM17_20 net54 vb4 vss sub sg13_lv_nmos w=1u l=1u m=1
RT984 vss sub ptap1 A=4e-12 P=8e-6
MM17_21 net54 vb4 vss sub sg13_lv_nmos w=1u l=1u m=1
RT985 vss sub ptap1 A=4e-12 P=8e-6
MM17_22 net54 vb4 vss sub sg13_lv_nmos w=1u l=1u m=1
RT986 vss sub ptap1 A=4e-12 P=8e-6
MM17_23 net54 vb4 vss sub sg13_lv_nmos w=1u l=1u m=1
RT987 vss sub ptap1 A=4e-12 P=8e-6
MM17_24 net54 vb4 vss sub sg13_lv_nmos w=1u l=1u m=1
RT988 vss sub ptap1 A=4e-12 P=8e-6
MM17_25 net54 vb4 vss sub sg13_lv_nmos w=1u l=1u m=1
RT989 vss sub ptap1 A=4e-12 P=8e-6
MM17_26 net54 vb4 vss sub sg13_lv_nmos w=1u l=1u m=1
RT990 vss sub ptap1 A=4e-12 P=8e-6
MM17_27 net54 vb4 vss sub sg13_lv_nmos w=1u l=1u m=1
RT991 vss sub ptap1 A=4e-12 P=8e-6
MM17_28 net54 vb4 vss sub sg13_lv_nmos w=1u l=1u m=1
RT992 vss sub ptap1 A=4e-12 P=8e-6
MM17_29 net54 vb4 vss sub sg13_lv_nmos w=1u l=1u m=1
RT993 vss sub ptap1 A=4e-12 P=8e-6
MM17_30 net54 vb4 vss sub sg13_lv_nmos w=1u l=1u m=1
RT994 vss sub ptap1 A=4e-12 P=8e-6
MM17_31 net54 vb4 vss sub sg13_lv_nmos w=1u l=1u m=1
RT995 vss sub ptap1 A=4e-12 P=8e-6
MM17_32 net54 vb4 vss sub sg13_lv_nmos w=1u l=1u m=1
RT996 vss sub ptap1 A=4e-12 P=8e-6
MM17_33 net54 vb4 vss sub sg13_lv_nmos w=1u l=1u m=1
RT997 vss sub ptap1 A=4e-12 P=8e-6
MM17_34 net54 vb4 vss sub sg13_lv_nmos w=1u l=1u m=1
RT998 vss sub ptap1 A=4e-12 P=8e-6
MM17_35 net54 vb4 vss sub sg13_lv_nmos w=1u l=1u m=1
RT999 vss sub ptap1 A=4e-12 P=8e-6
MM17_36 net54 vb4 vss sub sg13_lv_nmos w=1u l=1u m=1
RT1000 vss sub ptap1 A=4e-12 P=8e-6
MM17_37 net54 vb4 vss sub sg13_lv_nmos w=1u l=1u m=1
RT1001 vss sub ptap1 A=4e-12 P=8e-6
MM17_38 net54 vb4 vss sub sg13_lv_nmos w=1u l=1u m=1
RT1002 vss sub ptap1 A=4e-12 P=8e-6
MM17_39 net54 vb4 vss sub sg13_lv_nmos w=1u l=1u m=1
RT1003 vss sub ptap1 A=4e-12 P=8e-6
MM17_40 net54 vb4 vss sub sg13_lv_nmos w=1u l=1u m=1
RT1004 vss sub ptap1 A=4e-12 P=8e-6
MM17_41 net54 vb4 vss sub sg13_lv_nmos w=1u l=1u m=1
RT1005 vss sub ptap1 A=4e-12 P=8e-6
MM17_42 net54 vb4 vss sub sg13_lv_nmos w=1u l=1u m=1
RT1006 vss sub ptap1 A=4e-12 P=8e-6
MM17_43 net54 vb4 vss sub sg13_lv_nmos w=1u l=1u m=1
RT1007 vss sub ptap1 A=4e-12 P=8e-6
MM17_44 net54 vb4 vss sub sg13_lv_nmos w=1u l=1u m=1
RT1008 vss sub ptap1 A=4e-12 P=8e-6
MM17_45 net54 vb4 vss sub sg13_lv_nmos w=1u l=1u m=1
RT1009 vss sub ptap1 A=4e-12 P=8e-6
MM17_46 net54 vb4 vss sub sg13_lv_nmos w=1u l=1u m=1
RT1010 vss sub ptap1 A=4e-12 P=8e-6
MM17_47 net54 vb4 vss sub sg13_lv_nmos w=1u l=1u m=1
RT1011 vss sub ptap1 A=4e-12 P=8e-6
MM17_48 net54 vb4 vss sub sg13_lv_nmos w=1u l=1u m=1
RT1012 vss sub ptap1 A=4e-12 P=8e-6
MM17_49 net54 vb4 vss sub sg13_lv_nmos w=1u l=1u m=1
RT1013 vss sub ptap1 A=4e-12 P=8e-6
MM17_50 net54 vb4 vss sub sg13_lv_nmos w=1u l=1u m=1
RT1014 vss sub ptap1 A=4e-12 P=8e-6
MM17_51 net54 vb4 vss sub sg13_lv_nmos w=1u l=1u m=1
RT1015 vss sub ptap1 A=4e-12 P=8e-6
MM17_52 net54 vb4 vss sub sg13_lv_nmos w=1u l=1u m=1
RT1016 vss sub ptap1 A=4e-12 P=8e-6
MM17_53 net54 vb4 vss sub sg13_lv_nmos w=1u l=1u m=1
RT1017 vss sub ptap1 A=4e-12 P=8e-6
MM17_54 net54 vb4 vss sub sg13_lv_nmos w=1u l=1u m=1
RT1018 vss sub ptap1 A=4e-12 P=8e-6
MM17_55 net54 vb4 vss sub sg13_lv_nmos w=1u l=1u m=1
RT1019 vss sub ptap1 A=4e-12 P=8e-6
MM17_56 net54 vb4 vss sub sg13_lv_nmos w=1u l=1u m=1
RT1020 vss sub ptap1 A=4e-12 P=8e-6
MM17_57 net54 vb4 vss sub sg13_lv_nmos w=1u l=1u m=1
RT1021 vss sub ptap1 A=4e-12 P=8e-6
MM17_58 net54 vb4 vss sub sg13_lv_nmos w=1u l=1u m=1
RT1022 vss sub ptap1 A=4e-12 P=8e-6
MM17_59 net54 vb4 vss sub sg13_lv_nmos w=1u l=1u m=1
RT1023 vss sub ptap1 A=4e-12 P=8e-6
MM17_60 net54 vb4 vss sub sg13_lv_nmos w=1u l=1u m=1
RT1024 vss sub ptap1 A=4e-12 P=8e-6
MM17_61 net54 vb4 vss sub sg13_lv_nmos w=1u l=1u m=1
RT1025 vss sub ptap1 A=4e-12 P=8e-6
MM17_62 net54 vb4 vss sub sg13_lv_nmos w=1u l=1u m=1
RT1026 vss sub ptap1 A=4e-12 P=8e-6
MM17_63 net54 vb4 vss sub sg13_lv_nmos w=1u l=1u m=1
RT1027 vss sub ptap1 A=4e-12 P=8e-6
MM17_64 net54 vb4 vss sub sg13_lv_nmos w=1u l=1u m=1
RT1028 vss sub ptap1 A=4e-12 P=8e-6
MM17_65 net54 vb4 vss sub sg13_lv_nmos w=1u l=1u m=1
RT1029 vss sub ptap1 A=4e-12 P=8e-6
MM17_66 net54 vb4 vss sub sg13_lv_nmos w=1u l=1u m=1
RT1030 vss sub ptap1 A=4e-12 P=8e-6
MM17_67 net54 vb4 vss sub sg13_lv_nmos w=1u l=1u m=1
RT1031 vss sub ptap1 A=4e-12 P=8e-6
MM17_68 net54 vb4 vss sub sg13_lv_nmos w=1u l=1u m=1
RT1032 vss sub ptap1 A=4e-12 P=8e-6
MM17_69 net54 vb4 vss sub sg13_lv_nmos w=1u l=1u m=1
RT1033 vss sub ptap1 A=4e-12 P=8e-6
MM17_70 net54 vb4 vss sub sg13_lv_nmos w=1u l=1u m=1
RT1034 vss sub ptap1 A=4e-12 P=8e-6
MM17_71 net54 vb4 vss sub sg13_lv_nmos w=1u l=1u m=1
RT1035 vss sub ptap1 A=4e-12 P=8e-6
MM17_72 net54 vb4 vss sub sg13_lv_nmos w=1u l=1u m=1
RT1036 vss sub ptap1 A=4e-12 P=8e-6
MM17_73 net54 vb4 vss sub sg13_lv_nmos w=1u l=1u m=1
RT1037 vss sub ptap1 A=4e-12 P=8e-6
MM17_74 net54 vb4 vss sub sg13_lv_nmos w=1u l=1u m=1
RT1038 vss sub ptap1 A=4e-12 P=8e-6
MM17_75 net54 vb4 vss sub sg13_lv_nmos w=1u l=1u m=1
RT1039 vss sub ptap1 A=4e-12 P=8e-6
MM17_76 net54 vb4 vss sub sg13_lv_nmos w=1u l=1u m=1
RT1040 vss sub ptap1 A=4e-12 P=8e-6
MM17_77 net54 vb4 vss sub sg13_lv_nmos w=1u l=1u m=1
RT1041 vss sub ptap1 A=4e-12 P=8e-6
MM17_78 net54 vb4 vss sub sg13_lv_nmos w=1u l=1u m=1
RT1042 vss sub ptap1 A=4e-12 P=8e-6
MM17_79 net54 vb4 vss sub sg13_lv_nmos w=1u l=1u m=1
RT1043 vss sub ptap1 A=4e-12 P=8e-6
MM18_0 net56 vb4 vss sub sg13_lv_nmos w=1u l=1u m=1
RT1044 vss sub ptap1 A=4e-12 P=8e-6
MM18_1 net56 vb4 vss sub sg13_lv_nmos w=1u l=1u m=1
RT1045 vss sub ptap1 A=4e-12 P=8e-6
MM18_2 net56 vb4 vss sub sg13_lv_nmos w=1u l=1u m=1
RT1046 vss sub ptap1 A=4e-12 P=8e-6
MM18_3 net56 vb4 vss sub sg13_lv_nmos w=1u l=1u m=1
RT1047 vss sub ptap1 A=4e-12 P=8e-6
MM18_4 net56 vb4 vss sub sg13_lv_nmos w=1u l=1u m=1
RT1048 vss sub ptap1 A=4e-12 P=8e-6
MM18_5 net56 vb4 vss sub sg13_lv_nmos w=1u l=1u m=1
RT1049 vss sub ptap1 A=4e-12 P=8e-6
MM18_6 net56 vb4 vss sub sg13_lv_nmos w=1u l=1u m=1
RT1050 vss sub ptap1 A=4e-12 P=8e-6
MM18_7 net56 vb4 vss sub sg13_lv_nmos w=1u l=1u m=1
RT1051 vss sub ptap1 A=4e-12 P=8e-6
MM18_8 net56 vb4 vss sub sg13_lv_nmos w=1u l=1u m=1
RT1052 vss sub ptap1 A=4e-12 P=8e-6
MM18_9 net56 vb4 vss sub sg13_lv_nmos w=1u l=1u m=1
RT1053 vss sub ptap1 A=4e-12 P=8e-6
MM18_10 net56 vb4 vss sub sg13_lv_nmos w=1u l=1u m=1
RT1054 vss sub ptap1 A=4e-12 P=8e-6
MM18_11 net56 vb4 vss sub sg13_lv_nmos w=1u l=1u m=1
RT1055 vss sub ptap1 A=4e-12 P=8e-6
MM18_12 net56 vb4 vss sub sg13_lv_nmos w=1u l=1u m=1
RT1056 vss sub ptap1 A=4e-12 P=8e-6
MM18_13 net56 vb4 vss sub sg13_lv_nmos w=1u l=1u m=1
RT1057 vss sub ptap1 A=4e-12 P=8e-6
MM18_14 net56 vb4 vss sub sg13_lv_nmos w=1u l=1u m=1
RT1058 vss sub ptap1 A=4e-12 P=8e-6
MM18_15 net56 vb4 vss sub sg13_lv_nmos w=1u l=1u m=1
RT1059 vss sub ptap1 A=4e-12 P=8e-6
MM18_16 net56 vb4 vss sub sg13_lv_nmos w=1u l=1u m=1
RT1060 vss sub ptap1 A=4e-12 P=8e-6
MM18_17 net56 vb4 vss sub sg13_lv_nmos w=1u l=1u m=1
RT1061 vss sub ptap1 A=4e-12 P=8e-6
MM18_18 net56 vb4 vss sub sg13_lv_nmos w=1u l=1u m=1
RT1062 vss sub ptap1 A=4e-12 P=8e-6
MM18_19 net56 vb4 vss sub sg13_lv_nmos w=1u l=1u m=1
RT1063 vss sub ptap1 A=4e-12 P=8e-6
MM18_20 net56 vb4 vss sub sg13_lv_nmos w=1u l=1u m=1
RT1064 vss sub ptap1 A=4e-12 P=8e-6
MM18_21 net56 vb4 vss sub sg13_lv_nmos w=1u l=1u m=1
RT1065 vss sub ptap1 A=4e-12 P=8e-6
MM18_22 net56 vb4 vss sub sg13_lv_nmos w=1u l=1u m=1
RT1066 vss sub ptap1 A=4e-12 P=8e-6
MM18_23 net56 vb4 vss sub sg13_lv_nmos w=1u l=1u m=1
RT1067 vss sub ptap1 A=4e-12 P=8e-6
MM18_24 net56 vb4 vss sub sg13_lv_nmos w=1u l=1u m=1
RT1068 vss sub ptap1 A=4e-12 P=8e-6
MM18_25 net56 vb4 vss sub sg13_lv_nmos w=1u l=1u m=1
RT1069 vss sub ptap1 A=4e-12 P=8e-6
MM18_26 net56 vb4 vss sub sg13_lv_nmos w=1u l=1u m=1
RT1070 vss sub ptap1 A=4e-12 P=8e-6
MM18_27 net56 vb4 vss sub sg13_lv_nmos w=1u l=1u m=1
RT1071 vss sub ptap1 A=4e-12 P=8e-6
MM18_28 net56 vb4 vss sub sg13_lv_nmos w=1u l=1u m=1
RT1072 vss sub ptap1 A=4e-12 P=8e-6
MM18_29 net56 vb4 vss sub sg13_lv_nmos w=1u l=1u m=1
RT1073 vss sub ptap1 A=4e-12 P=8e-6
MM18_30 net56 vb4 vss sub sg13_lv_nmos w=1u l=1u m=1
RT1074 vss sub ptap1 A=4e-12 P=8e-6
MM18_31 net56 vb4 vss sub sg13_lv_nmos w=1u l=1u m=1
RT1075 vss sub ptap1 A=4e-12 P=8e-6
MM18_32 net56 vb4 vss sub sg13_lv_nmos w=1u l=1u m=1
RT1076 vss sub ptap1 A=4e-12 P=8e-6
MM18_33 net56 vb4 vss sub sg13_lv_nmos w=1u l=1u m=1
RT1077 vss sub ptap1 A=4e-12 P=8e-6
MM18_34 net56 vb4 vss sub sg13_lv_nmos w=1u l=1u m=1
RT1078 vss sub ptap1 A=4e-12 P=8e-6
MM18_35 net56 vb4 vss sub sg13_lv_nmos w=1u l=1u m=1
RT1079 vss sub ptap1 A=4e-12 P=8e-6
MM18_36 net56 vb4 vss sub sg13_lv_nmos w=1u l=1u m=1
RT1080 vss sub ptap1 A=4e-12 P=8e-6
MM18_37 net56 vb4 vss sub sg13_lv_nmos w=1u l=1u m=1
RT1081 vss sub ptap1 A=4e-12 P=8e-6
MM18_38 net56 vb4 vss sub sg13_lv_nmos w=1u l=1u m=1
RT1082 vss sub ptap1 A=4e-12 P=8e-6
MM18_39 net56 vb4 vss sub sg13_lv_nmos w=1u l=1u m=1
RT1083 vss sub ptap1 A=4e-12 P=8e-6
MM18_40 net56 vb4 vss sub sg13_lv_nmos w=1u l=1u m=1
RT1084 vss sub ptap1 A=4e-12 P=8e-6
MM18_41 net56 vb4 vss sub sg13_lv_nmos w=1u l=1u m=1
RT1085 vss sub ptap1 A=4e-12 P=8e-6
MM18_42 net56 vb4 vss sub sg13_lv_nmos w=1u l=1u m=1
RT1086 vss sub ptap1 A=4e-12 P=8e-6
MM18_43 net56 vb4 vss sub sg13_lv_nmos w=1u l=1u m=1
RT1087 vss sub ptap1 A=4e-12 P=8e-6
MM18_44 net56 vb4 vss sub sg13_lv_nmos w=1u l=1u m=1
RT1088 vss sub ptap1 A=4e-12 P=8e-6
MM18_45 net56 vb4 vss sub sg13_lv_nmos w=1u l=1u m=1
RT1089 vss sub ptap1 A=4e-12 P=8e-6
MM18_46 net56 vb4 vss sub sg13_lv_nmos w=1u l=1u m=1
RT1090 vss sub ptap1 A=4e-12 P=8e-6
MM18_47 net56 vb4 vss sub sg13_lv_nmos w=1u l=1u m=1
RT1091 vss sub ptap1 A=4e-12 P=8e-6
MM18_48 net56 vb4 vss sub sg13_lv_nmos w=1u l=1u m=1
RT1092 vss sub ptap1 A=4e-12 P=8e-6
MM18_49 net56 vb4 vss sub sg13_lv_nmos w=1u l=1u m=1
RT1093 vss sub ptap1 A=4e-12 P=8e-6
MM18_50 net56 vb4 vss sub sg13_lv_nmos w=1u l=1u m=1
RT1094 vss sub ptap1 A=4e-12 P=8e-6
MM18_51 net56 vb4 vss sub sg13_lv_nmos w=1u l=1u m=1
RT1095 vss sub ptap1 A=4e-12 P=8e-6
MM18_52 net56 vb4 vss sub sg13_lv_nmos w=1u l=1u m=1
RT1096 vss sub ptap1 A=4e-12 P=8e-6
MM18_53 net56 vb4 vss sub sg13_lv_nmos w=1u l=1u m=1
RT1097 vss sub ptap1 A=4e-12 P=8e-6
MM18_54 net56 vb4 vss sub sg13_lv_nmos w=1u l=1u m=1
RT1098 vss sub ptap1 A=4e-12 P=8e-6
MM18_55 net56 vb4 vss sub sg13_lv_nmos w=1u l=1u m=1
RT1099 vss sub ptap1 A=4e-12 P=8e-6
MM18_56 net56 vb4 vss sub sg13_lv_nmos w=1u l=1u m=1
RT1100 vss sub ptap1 A=4e-12 P=8e-6
MM18_57 net56 vb4 vss sub sg13_lv_nmos w=1u l=1u m=1
RT1101 vss sub ptap1 A=4e-12 P=8e-6
MM18_58 net56 vb4 vss sub sg13_lv_nmos w=1u l=1u m=1
RT1102 vss sub ptap1 A=4e-12 P=8e-6
MM18_59 net56 vb4 vss sub sg13_lv_nmos w=1u l=1u m=1
RT1103 vss sub ptap1 A=4e-12 P=8e-6
MM18_60 net56 vb4 vss sub sg13_lv_nmos w=1u l=1u m=1
RT1104 vss sub ptap1 A=4e-12 P=8e-6
MM18_61 net56 vb4 vss sub sg13_lv_nmos w=1u l=1u m=1
RT1105 vss sub ptap1 A=4e-12 P=8e-6
MM18_62 net56 vb4 vss sub sg13_lv_nmos w=1u l=1u m=1
RT1106 vss sub ptap1 A=4e-12 P=8e-6
MM18_63 net56 vb4 vss sub sg13_lv_nmos w=1u l=1u m=1
RT1107 vss sub ptap1 A=4e-12 P=8e-6
MM18_64 net56 vb4 vss sub sg13_lv_nmos w=1u l=1u m=1
RT1108 vss sub ptap1 A=4e-12 P=8e-6
MM18_65 net56 vb4 vss sub sg13_lv_nmos w=1u l=1u m=1
RT1109 vss sub ptap1 A=4e-12 P=8e-6
MM18_66 net56 vb4 vss sub sg13_lv_nmos w=1u l=1u m=1
RT1110 vss sub ptap1 A=4e-12 P=8e-6
MM18_67 net56 vb4 vss sub sg13_lv_nmos w=1u l=1u m=1
RT1111 vss sub ptap1 A=4e-12 P=8e-6
MM18_68 net56 vb4 vss sub sg13_lv_nmos w=1u l=1u m=1
RT1112 vss sub ptap1 A=4e-12 P=8e-6
MM18_69 net56 vb4 vss sub sg13_lv_nmos w=1u l=1u m=1
RT1113 vss sub ptap1 A=4e-12 P=8e-6
MM18_70 net56 vb4 vss sub sg13_lv_nmos w=1u l=1u m=1
RT1114 vss sub ptap1 A=4e-12 P=8e-6
MM18_71 net56 vb4 vss sub sg13_lv_nmos w=1u l=1u m=1
RT1115 vss sub ptap1 A=4e-12 P=8e-6
MM18_72 net56 vb4 vss sub sg13_lv_nmos w=1u l=1u m=1
RT1116 vss sub ptap1 A=4e-12 P=8e-6
MM18_73 net56 vb4 vss sub sg13_lv_nmos w=1u l=1u m=1
RT1117 vss sub ptap1 A=4e-12 P=8e-6
MM18_74 net56 vb4 vss sub sg13_lv_nmos w=1u l=1u m=1
RT1118 vss sub ptap1 A=4e-12 P=8e-6
MM18_75 net56 vb4 vss sub sg13_lv_nmos w=1u l=1u m=1
RT1119 vss sub ptap1 A=4e-12 P=8e-6
MM18_76 net56 vb4 vss sub sg13_lv_nmos w=1u l=1u m=1
RT1120 vss sub ptap1 A=4e-12 P=8e-6
MM18_77 net56 vb4 vss sub sg13_lv_nmos w=1u l=1u m=1
RT1121 vss sub ptap1 A=4e-12 P=8e-6
MM18_78 net56 vb4 vss sub sg13_lv_nmos w=1u l=1u m=1
RT1122 vss sub ptap1 A=4e-12 P=8e-6
MM18_79 net56 vb4 vss sub sg13_lv_nmos w=1u l=1u m=1
RT1123 vss sub ptap1 A=4e-12 P=8e-6
MM19_0 dm_2 vb4 vss sub sg13_lv_nmos w=1u l=1u m=1
RT1124 vss sub ptap1 A=4e-12 P=8e-6
MM19_1 dm_2 vb4 vss sub sg13_lv_nmos w=1u l=1u m=1
RT1125 vss sub ptap1 A=4e-12 P=8e-6
MM19_2 dm_2 vb4 vss sub sg13_lv_nmos w=1u l=1u m=1
RT1126 vss sub ptap1 A=4e-12 P=8e-6
MM19_3 dm_2 vb4 vss sub sg13_lv_nmos w=1u l=1u m=1
RT1127 vss sub ptap1 A=4e-12 P=8e-6
MM19_4 dm_2 vb4 vss sub sg13_lv_nmos w=1u l=1u m=1
RT1128 vss sub ptap1 A=4e-12 P=8e-6
MM19_5 dm_2 vb4 vss sub sg13_lv_nmos w=1u l=1u m=1
RT1129 vss sub ptap1 A=4e-12 P=8e-6
MM19_6 dm_2 vb4 vss sub sg13_lv_nmos w=1u l=1u m=1
RT1130 vss sub ptap1 A=4e-12 P=8e-6
MM19_7 dm_2 vb4 vss sub sg13_lv_nmos w=1u l=1u m=1
RT1131 vss sub ptap1 A=4e-12 P=8e-6
MM19_8 dm_2 vb4 vss sub sg13_lv_nmos w=1u l=1u m=1
RT1132 vss sub ptap1 A=4e-12 P=8e-6
MM19_9 dm_2 vb4 vss sub sg13_lv_nmos w=1u l=1u m=1
RT1133 vss sub ptap1 A=4e-12 P=8e-6
MM19_10 dm_2 vb4 vss sub sg13_lv_nmos w=1u l=1u m=1
RT1134 vss sub ptap1 A=4e-12 P=8e-6
MM19_11 dm_2 vb4 vss sub sg13_lv_nmos w=1u l=1u m=1
RT1135 vss sub ptap1 A=4e-12 P=8e-6
MM19_12 dm_2 vb4 vss sub sg13_lv_nmos w=1u l=1u m=1
RT1136 vss sub ptap1 A=4e-12 P=8e-6
MM19_13 dm_2 vb4 vss sub sg13_lv_nmos w=1u l=1u m=1
RT1137 vss sub ptap1 A=4e-12 P=8e-6
MM19_14 dm_2 vb4 vss sub sg13_lv_nmos w=1u l=1u m=1
RT1138 vss sub ptap1 A=4e-12 P=8e-6
MM19_15 dm_2 vb4 vss sub sg13_lv_nmos w=1u l=1u m=1
RT1139 vss sub ptap1 A=4e-12 P=8e-6
MM19_16 dm_2 vb4 vss sub sg13_lv_nmos w=1u l=1u m=1
RT1140 vss sub ptap1 A=4e-12 P=8e-6
MM19_17 dm_2 vb4 vss sub sg13_lv_nmos w=1u l=1u m=1
RT1141 vss sub ptap1 A=4e-12 P=8e-6
MM19_18 dm_2 vb4 vss sub sg13_lv_nmos w=1u l=1u m=1
RT1142 vss sub ptap1 A=4e-12 P=8e-6
MM19_19 dm_2 vb4 vss sub sg13_lv_nmos w=1u l=1u m=1
RT1143 vss sub ptap1 A=4e-12 P=8e-6
MM19_20 dm_2 vb4 vss sub sg13_lv_nmos w=1u l=1u m=1
RT1144 vss sub ptap1 A=4e-12 P=8e-6
MM19_21 dm_2 vb4 vss sub sg13_lv_nmos w=1u l=1u m=1
RT1145 vss sub ptap1 A=4e-12 P=8e-6
MM19_22 dm_2 vb4 vss sub sg13_lv_nmos w=1u l=1u m=1
RT1146 vss sub ptap1 A=4e-12 P=8e-6
MM19_23 dm_2 vb4 vss sub sg13_lv_nmos w=1u l=1u m=1
RT1147 vss sub ptap1 A=4e-12 P=8e-6
MM19_24 dm_2 vb4 vss sub sg13_lv_nmos w=1u l=1u m=1
RT1148 vss sub ptap1 A=4e-12 P=8e-6
MM19_25 dm_2 vb4 vss sub sg13_lv_nmos w=1u l=1u m=1
RT1149 vss sub ptap1 A=4e-12 P=8e-6
MM19_26 dm_2 vb4 vss sub sg13_lv_nmos w=1u l=1u m=1
RT1150 vss sub ptap1 A=4e-12 P=8e-6
MM19_27 dm_2 vb4 vss sub sg13_lv_nmos w=1u l=1u m=1
RT1151 vss sub ptap1 A=4e-12 P=8e-6
MM19_28 dm_2 vb4 vss sub sg13_lv_nmos w=1u l=1u m=1
RT1152 vss sub ptap1 A=4e-12 P=8e-6
MM19_29 dm_2 vb4 vss sub sg13_lv_nmos w=1u l=1u m=1
RT1153 vss sub ptap1 A=4e-12 P=8e-6
MM19_30 dm_2 vb4 vss sub sg13_lv_nmos w=1u l=1u m=1
RT1154 vss sub ptap1 A=4e-12 P=8e-6
MM19_31 dm_2 vb4 vss sub sg13_lv_nmos w=1u l=1u m=1
RT1155 vss sub ptap1 A=4e-12 P=8e-6
MM19_32 dm_2 vb4 vss sub sg13_lv_nmos w=1u l=1u m=1
RT1156 vss sub ptap1 A=4e-12 P=8e-6
MM19_33 dm_2 vb4 vss sub sg13_lv_nmos w=1u l=1u m=1
RT1157 vss sub ptap1 A=4e-12 P=8e-6
MM19_34 dm_2 vb4 vss sub sg13_lv_nmos w=1u l=1u m=1
RT1158 vss sub ptap1 A=4e-12 P=8e-6
MM19_35 dm_2 vb4 vss sub sg13_lv_nmos w=1u l=1u m=1
RT1159 vss sub ptap1 A=4e-12 P=8e-6
MM19_36 dm_2 vb4 vss sub sg13_lv_nmos w=1u l=1u m=1
RT1160 vss sub ptap1 A=4e-12 P=8e-6
MM19_37 dm_2 vb4 vss sub sg13_lv_nmos w=1u l=1u m=1
RT1161 vss sub ptap1 A=4e-12 P=8e-6
MM19_38 dm_2 vb4 vss sub sg13_lv_nmos w=1u l=1u m=1
RT1162 vss sub ptap1 A=4e-12 P=8e-6
MM19_39 dm_2 vb4 vss sub sg13_lv_nmos w=1u l=1u m=1
RT1163 vss sub ptap1 A=4e-12 P=8e-6
MM19_40 dm_2 vb4 vss sub sg13_lv_nmos w=1u l=1u m=1
RT1164 vss sub ptap1 A=4e-12 P=8e-6
MM19_41 dm_2 vb4 vss sub sg13_lv_nmos w=1u l=1u m=1
RT1165 vss sub ptap1 A=4e-12 P=8e-6
MM19_42 dm_2 vb4 vss sub sg13_lv_nmos w=1u l=1u m=1
RT1166 vss sub ptap1 A=4e-12 P=8e-6
MM19_43 dm_2 vb4 vss sub sg13_lv_nmos w=1u l=1u m=1
RT1167 vss sub ptap1 A=4e-12 P=8e-6
MM19_44 dm_2 vb4 vss sub sg13_lv_nmos w=1u l=1u m=1
RT1168 vss sub ptap1 A=4e-12 P=8e-6
MM19_45 dm_2 vb4 vss sub sg13_lv_nmos w=1u l=1u m=1
RT1169 vss sub ptap1 A=4e-12 P=8e-6
MM19_46 dm_2 vb4 vss sub sg13_lv_nmos w=1u l=1u m=1
RT1170 vss sub ptap1 A=4e-12 P=8e-6
MM19_47 dm_2 vb4 vss sub sg13_lv_nmos w=1u l=1u m=1
RT1171 vss sub ptap1 A=4e-12 P=8e-6
MM19_48 dm_2 vb4 vss sub sg13_lv_nmos w=1u l=1u m=1
RT1172 vss sub ptap1 A=4e-12 P=8e-6
MM19_49 dm_2 vb4 vss sub sg13_lv_nmos w=1u l=1u m=1
RT1173 vss sub ptap1 A=4e-12 P=8e-6
MM19_50 dm_2 vb4 vss sub sg13_lv_nmos w=1u l=1u m=1
RT1174 vss sub ptap1 A=4e-12 P=8e-6
MM19_51 dm_2 vb4 vss sub sg13_lv_nmos w=1u l=1u m=1
RT1175 vss sub ptap1 A=4e-12 P=8e-6
MM19_52 dm_2 vb4 vss sub sg13_lv_nmos w=1u l=1u m=1
RT1176 vss sub ptap1 A=4e-12 P=8e-6
MM19_53 dm_2 vb4 vss sub sg13_lv_nmos w=1u l=1u m=1
RT1177 vss sub ptap1 A=4e-12 P=8e-6
MM19_54 dm_2 vb4 vss sub sg13_lv_nmos w=1u l=1u m=1
RT1178 vss sub ptap1 A=4e-12 P=8e-6
MM19_55 dm_2 vb4 vss sub sg13_lv_nmos w=1u l=1u m=1
RT1179 vss sub ptap1 A=4e-12 P=8e-6
MM19_56 dm_2 vb4 vss sub sg13_lv_nmos w=1u l=1u m=1
RT1180 vss sub ptap1 A=4e-12 P=8e-6
MM19_57 dm_2 vb4 vss sub sg13_lv_nmos w=1u l=1u m=1
RT1181 vss sub ptap1 A=4e-12 P=8e-6
MM19_58 dm_2 vb4 vss sub sg13_lv_nmos w=1u l=1u m=1
RT1182 vss sub ptap1 A=4e-12 P=8e-6
MM19_59 dm_2 vb4 vss sub sg13_lv_nmos w=1u l=1u m=1
RT1183 vss sub ptap1 A=4e-12 P=8e-6
MM19_60 dm_2 vb4 vss sub sg13_lv_nmos w=1u l=1u m=1
RT1184 vss sub ptap1 A=4e-12 P=8e-6
MM19_61 dm_2 vb4 vss sub sg13_lv_nmos w=1u l=1u m=1
RT1185 vss sub ptap1 A=4e-12 P=8e-6
MM19_62 dm_2 vb4 vss sub sg13_lv_nmos w=1u l=1u m=1
RT1186 vss sub ptap1 A=4e-12 P=8e-6
MM19_63 dm_2 vb4 vss sub sg13_lv_nmos w=1u l=1u m=1
RT1187 vss sub ptap1 A=4e-12 P=8e-6
MM19_64 dm_2 vb4 vss sub sg13_lv_nmos w=1u l=1u m=1
RT1188 vss sub ptap1 A=4e-12 P=8e-6
MM19_65 dm_2 vb4 vss sub sg13_lv_nmos w=1u l=1u m=1
RT1189 vss sub ptap1 A=4e-12 P=8e-6
MM19_66 dm_2 vb4 vss sub sg13_lv_nmos w=1u l=1u m=1
RT1190 vss sub ptap1 A=4e-12 P=8e-6
MM19_67 dm_2 vb4 vss sub sg13_lv_nmos w=1u l=1u m=1
RT1191 vss sub ptap1 A=4e-12 P=8e-6
MM19_68 dm_2 vb4 vss sub sg13_lv_nmos w=1u l=1u m=1
RT1192 vss sub ptap1 A=4e-12 P=8e-6
MM19_69 dm_2 vb4 vss sub sg13_lv_nmos w=1u l=1u m=1
RT1193 vss sub ptap1 A=4e-12 P=8e-6
MM19_70 dm_2 vb4 vss sub sg13_lv_nmos w=1u l=1u m=1
RT1194 vss sub ptap1 A=4e-12 P=8e-6
MM19_71 dm_2 vb4 vss sub sg13_lv_nmos w=1u l=1u m=1
RT1195 vss sub ptap1 A=4e-12 P=8e-6
MM19_72 dm_2 vb4 vss sub sg13_lv_nmos w=1u l=1u m=1
RT1196 vss sub ptap1 A=4e-12 P=8e-6
MM19_73 dm_2 vb4 vss sub sg13_lv_nmos w=1u l=1u m=1
RT1197 vss sub ptap1 A=4e-12 P=8e-6
MM19_74 dm_2 vb4 vss sub sg13_lv_nmos w=1u l=1u m=1
RT1198 vss sub ptap1 A=4e-12 P=8e-6
MM19_75 dm_2 vb4 vss sub sg13_lv_nmos w=1u l=1u m=1
RT1199 vss sub ptap1 A=4e-12 P=8e-6
MM19_76 dm_2 vb4 vss sub sg13_lv_nmos w=1u l=1u m=1
RT1200 vss sub ptap1 A=4e-12 P=8e-6
MM19_77 dm_2 vb4 vss sub sg13_lv_nmos w=1u l=1u m=1
RT1201 vss sub ptap1 A=4e-12 P=8e-6
MM19_78 dm_2 vb4 vss sub sg13_lv_nmos w=1u l=1u m=1
RT1202 vss sub ptap1 A=4e-12 P=8e-6
MM19_79 dm_2 vb4 vss sub sg13_lv_nmos w=1u l=1u m=1
RT1203 vss sub ptap1 A=4e-12 P=8e-6
MM19_80 dm_2 vb4 vss sub sg13_lv_nmos w=1u l=1u m=1
RT1204 vss sub ptap1 A=4e-12 P=8e-6
MM19_81 dm_2 vb4 vss sub sg13_lv_nmos w=1u l=1u m=1
RT1205 vss sub ptap1 A=4e-12 P=8e-6
MM19_82 dm_2 vb4 vss sub sg13_lv_nmos w=1u l=1u m=1
RT1206 vss sub ptap1 A=4e-12 P=8e-6
MM19_83 dm_2 vb4 vss sub sg13_lv_nmos w=1u l=1u m=1
RT1207 vss sub ptap1 A=4e-12 P=8e-6
MM19_84 dm_2 vb4 vss sub sg13_lv_nmos w=1u l=1u m=1
RT1208 vss sub ptap1 A=4e-12 P=8e-6
MM19_85 dm_2 vb4 vss sub sg13_lv_nmos w=1u l=1u m=1
RT1209 vss sub ptap1 A=4e-12 P=8e-6
MM19_86 dm_2 vb4 vss sub sg13_lv_nmos w=1u l=1u m=1
RT1210 vss sub ptap1 A=4e-12 P=8e-6
MM19_87 dm_2 vb4 vss sub sg13_lv_nmos w=1u l=1u m=1
RT1211 vss sub ptap1 A=4e-12 P=8e-6
MM19_88 dm_2 vb4 vss sub sg13_lv_nmos w=1u l=1u m=1
RT1212 vss sub ptap1 A=4e-12 P=8e-6
MM19_89 dm_2 vb4 vss sub sg13_lv_nmos w=1u l=1u m=1
RT1213 vss sub ptap1 A=4e-12 P=8e-6
MM19_90 dm_2 vb4 vss sub sg13_lv_nmos w=1u l=1u m=1
RT1214 vss sub ptap1 A=4e-12 P=8e-6
MM19_91 dm_2 vb4 vss sub sg13_lv_nmos w=1u l=1u m=1
RT1215 vss sub ptap1 A=4e-12 P=8e-6
MM19_92 dm_2 vb4 vss sub sg13_lv_nmos w=1u l=1u m=1
RT1216 vss sub ptap1 A=4e-12 P=8e-6
MM19_93 dm_2 vb4 vss sub sg13_lv_nmos w=1u l=1u m=1
RT1217 vss sub ptap1 A=4e-12 P=8e-6
MM19_94 dm_2 vb4 vss sub sg13_lv_nmos w=1u l=1u m=1
RT1218 vss sub ptap1 A=4e-12 P=8e-6
MM19_95 dm_2 vb4 vss sub sg13_lv_nmos w=1u l=1u m=1
RT1219 vss sub ptap1 A=4e-12 P=8e-6
MM19_96 dm_2 vb4 vss sub sg13_lv_nmos w=1u l=1u m=1
RT1220 vss sub ptap1 A=4e-12 P=8e-6
MM19_97 dm_2 vb4 vss sub sg13_lv_nmos w=1u l=1u m=1
RT1221 vss sub ptap1 A=4e-12 P=8e-6
MM19_98 dm_2 vb4 vss sub sg13_lv_nmos w=1u l=1u m=1
RT1222 vss sub ptap1 A=4e-12 P=8e-6
MM19_99 dm_2 vb4 vss sub sg13_lv_nmos w=1u l=1u m=1
RT1223 vss sub ptap1 A=4e-12 P=8e-6
MM19_100 dm_2 vb4 vss sub sg13_lv_nmos w=1u l=1u m=1
RT1224 vss sub ptap1 A=4e-12 P=8e-6
MM19_101 dm_2 vb4 vss sub sg13_lv_nmos w=1u l=1u m=1
RT1225 vss sub ptap1 A=4e-12 P=8e-6
MM19_102 dm_2 vb4 vss sub sg13_lv_nmos w=1u l=1u m=1
RT1226 vss sub ptap1 A=4e-12 P=8e-6
MM19_103 dm_2 vb4 vss sub sg13_lv_nmos w=1u l=1u m=1
RT1227 vss sub ptap1 A=4e-12 P=8e-6
MM19_104 dm_2 vb4 vss sub sg13_lv_nmos w=1u l=1u m=1
RT1228 vss sub ptap1 A=4e-12 P=8e-6
MM19_105 dm_2 vb4 vss sub sg13_lv_nmos w=1u l=1u m=1
RT1229 vss sub ptap1 A=4e-12 P=8e-6
MM19_106 dm_2 vb4 vss sub sg13_lv_nmos w=1u l=1u m=1
RT1230 vss sub ptap1 A=4e-12 P=8e-6
MM19_107 dm_2 vb4 vss sub sg13_lv_nmos w=1u l=1u m=1
RT1231 vss sub ptap1 A=4e-12 P=8e-6
MM19_108 dm_2 vb4 vss sub sg13_lv_nmos w=1u l=1u m=1
RT1232 vss sub ptap1 A=4e-12 P=8e-6
MM19_109 dm_2 vb4 vss sub sg13_lv_nmos w=1u l=1u m=1
RT1233 vss sub ptap1 A=4e-12 P=8e-6
MM19_110 dm_2 vb4 vss sub sg13_lv_nmos w=1u l=1u m=1
RT1234 vss sub ptap1 A=4e-12 P=8e-6
MM19_111 dm_2 vb4 vss sub sg13_lv_nmos w=1u l=1u m=1
RT1235 vss sub ptap1 A=4e-12 P=8e-6
MM19_112 dm_2 vb4 vss sub sg13_lv_nmos w=1u l=1u m=1
RT1236 vss sub ptap1 A=4e-12 P=8e-6
MM19_113 dm_2 vb4 vss sub sg13_lv_nmos w=1u l=1u m=1
RT1237 vss sub ptap1 A=4e-12 P=8e-6
MM19_114 dm_2 vb4 vss sub sg13_lv_nmos w=1u l=1u m=1
RT1238 vss sub ptap1 A=4e-12 P=8e-6
MM19_115 dm_2 vb4 vss sub sg13_lv_nmos w=1u l=1u m=1
RT1239 vss sub ptap1 A=4e-12 P=8e-6
MM19_116 dm_2 vb4 vss sub sg13_lv_nmos w=1u l=1u m=1
RT1240 vss sub ptap1 A=4e-12 P=8e-6
MM19_117 dm_2 vb4 vss sub sg13_lv_nmos w=1u l=1u m=1
RT1241 vss sub ptap1 A=4e-12 P=8e-6
MM19_118 dm_2 vb4 vss sub sg13_lv_nmos w=1u l=1u m=1
RT1242 vss sub ptap1 A=4e-12 P=8e-6
MM19_119 dm_2 vb4 vss sub sg13_lv_nmos w=1u l=1u m=1
RT1243 vss sub ptap1 A=4e-12 P=8e-6
MM19_120 dm_2 vb4 vss sub sg13_lv_nmos w=1u l=1u m=1
RT1244 vss sub ptap1 A=4e-12 P=8e-6
MM19_121 dm_2 vb4 vss sub sg13_lv_nmos w=1u l=1u m=1
RT1245 vss sub ptap1 A=4e-12 P=8e-6
MM19_122 dm_2 vb4 vss sub sg13_lv_nmos w=1u l=1u m=1
RT1246 vss sub ptap1 A=4e-12 P=8e-6
MM19_123 dm_2 vb4 vss sub sg13_lv_nmos w=1u l=1u m=1
RT1247 vss sub ptap1 A=4e-12 P=8e-6
MM19_124 dm_2 vb4 vss sub sg13_lv_nmos w=1u l=1u m=1
RT1248 vss sub ptap1 A=4e-12 P=8e-6
MM19_125 dm_2 vb4 vss sub sg13_lv_nmos w=1u l=1u m=1
RT1249 vss sub ptap1 A=4e-12 P=8e-6
MM19_126 dm_2 vb4 vss sub sg13_lv_nmos w=1u l=1u m=1
RT1250 vss sub ptap1 A=4e-12 P=8e-6
MM19_127 dm_2 vb4 vss sub sg13_lv_nmos w=1u l=1u m=1
RT1251 vss sub ptap1 A=4e-12 P=8e-6
MM19_128 dm_2 vb4 vss sub sg13_lv_nmos w=1u l=1u m=1
RT1252 vss sub ptap1 A=4e-12 P=8e-6
MM19_129 dm_2 vb4 vss sub sg13_lv_nmos w=1u l=1u m=1
RT1253 vss sub ptap1 A=4e-12 P=8e-6
MM19_130 dm_2 vb4 vss sub sg13_lv_nmos w=1u l=1u m=1
RT1254 vss sub ptap1 A=4e-12 P=8e-6
MM19_131 dm_2 vb4 vss sub sg13_lv_nmos w=1u l=1u m=1
RT1255 vss sub ptap1 A=4e-12 P=8e-6
MM19_132 dm_2 vb4 vss sub sg13_lv_nmos w=1u l=1u m=1
RT1256 vss sub ptap1 A=4e-12 P=8e-6
MM19_133 dm_2 vb4 vss sub sg13_lv_nmos w=1u l=1u m=1
RT1257 vss sub ptap1 A=4e-12 P=8e-6
MM19_134 dm_2 vb4 vss sub sg13_lv_nmos w=1u l=1u m=1
RT1258 vss sub ptap1 A=4e-12 P=8e-6
MM19_135 dm_2 vb4 vss sub sg13_lv_nmos w=1u l=1u m=1
RT1259 vss sub ptap1 A=4e-12 P=8e-6
MM19_136 dm_2 vb4 vss sub sg13_lv_nmos w=1u l=1u m=1
RT1260 vss sub ptap1 A=4e-12 P=8e-6
MM19_137 dm_2 vb4 vss sub sg13_lv_nmos w=1u l=1u m=1
RT1261 vss sub ptap1 A=4e-12 P=8e-6
MM19_138 dm_2 vb4 vss sub sg13_lv_nmos w=1u l=1u m=1
RT1262 vss sub ptap1 A=4e-12 P=8e-6
MM19_139 dm_2 vb4 vss sub sg13_lv_nmos w=1u l=1u m=1
RT1263 vss sub ptap1 A=4e-12 P=8e-6
MM19_140 dm_2 vb4 vss sub sg13_lv_nmos w=1u l=1u m=1
RT1264 vss sub ptap1 A=4e-12 P=8e-6
MM19_141 dm_2 vb4 vss sub sg13_lv_nmos w=1u l=1u m=1
RT1265 vss sub ptap1 A=4e-12 P=8e-6
MM19_142 dm_2 vb4 vss sub sg13_lv_nmos w=1u l=1u m=1
RT1266 vss sub ptap1 A=4e-12 P=8e-6
MM19_143 dm_2 vb4 vss sub sg13_lv_nmos w=1u l=1u m=1
RT1267 vss sub ptap1 A=4e-12 P=8e-6
MM19_144 dm_2 vb4 vss sub sg13_lv_nmos w=1u l=1u m=1
RT1268 vss sub ptap1 A=4e-12 P=8e-6
MM19_145 dm_2 vb4 vss sub sg13_lv_nmos w=1u l=1u m=1
RT1269 vss sub ptap1 A=4e-12 P=8e-6
MM19_146 dm_2 vb4 vss sub sg13_lv_nmos w=1u l=1u m=1
RT1270 vss sub ptap1 A=4e-12 P=8e-6
MM19_147 dm_2 vb4 vss sub sg13_lv_nmos w=1u l=1u m=1
RT1271 vss sub ptap1 A=4e-12 P=8e-6
MM19_148 dm_2 vb4 vss sub sg13_lv_nmos w=1u l=1u m=1
RT1272 vss sub ptap1 A=4e-12 P=8e-6
MM19_149 dm_2 vb4 vss sub sg13_lv_nmos w=1u l=1u m=1
RT1273 vss sub ptap1 A=4e-12 P=8e-6
MM19_150 dm_2 vb4 vss sub sg13_lv_nmos w=1u l=1u m=1
RT1274 vss sub ptap1 A=4e-12 P=8e-6
MM19_151 dm_2 vb4 vss sub sg13_lv_nmos w=1u l=1u m=1
RT1275 vss sub ptap1 A=4e-12 P=8e-6
MM19_152 dm_2 vb4 vss sub sg13_lv_nmos w=1u l=1u m=1
RT1276 vss sub ptap1 A=4e-12 P=8e-6
MM19_153 dm_2 vb4 vss sub sg13_lv_nmos w=1u l=1u m=1
RT1277 vss sub ptap1 A=4e-12 P=8e-6
MM19_154 dm_2 vb4 vss sub sg13_lv_nmos w=1u l=1u m=1
RT1278 vss sub ptap1 A=4e-12 P=8e-6
MM19_155 dm_2 vb4 vss sub sg13_lv_nmos w=1u l=1u m=1
RT1279 vss sub ptap1 A=4e-12 P=8e-6
MM19_156 dm_2 vb4 vss sub sg13_lv_nmos w=1u l=1u m=1
RT1280 vss sub ptap1 A=4e-12 P=8e-6
MM19_157 dm_2 vb4 vss sub sg13_lv_nmos w=1u l=1u m=1
RT1281 vss sub ptap1 A=4e-12 P=8e-6
MM19_158 dm_2 vb4 vss sub sg13_lv_nmos w=1u l=1u m=1
RT1282 vss sub ptap1 A=4e-12 P=8e-6
MM19_159 dm_2 vb4 vss sub sg13_lv_nmos w=1u l=1u m=1
RT1283 vdd well_1283 ntap1 A=4e-12 P=8e-6
MM2_0 dm_1 net1 vdd well_1283 sg13_lv_pmos w=1u l=1u m=1
RT1284 vdd well_1284 ntap1 A=4e-12 P=8e-6
MM2_1 dm_1 net1 vdd well_1284 sg13_lv_pmos w=1u l=1u m=1
RT1285 vdd well_1285 ntap1 A=4e-12 P=8e-6
MM2_2 dm_1 net1 vdd well_1285 sg13_lv_pmos w=1u l=1u m=1
RT1286 vdd well_1286 ntap1 A=4e-12 P=8e-6
MM2_3 dm_1 net1 vdd well_1286 sg13_lv_pmos w=1u l=1u m=1
RT1287 vdd well_1287 ntap1 A=4e-12 P=8e-6
MM2_4 dm_1 net1 vdd well_1287 sg13_lv_pmos w=1u l=1u m=1
RT1288 vdd well_1288 ntap1 A=4e-12 P=8e-6
MM2_5 dm_1 net1 vdd well_1288 sg13_lv_pmos w=1u l=1u m=1
RT1289 vdd well_1289 ntap1 A=4e-12 P=8e-6
MM2_6 dm_1 net1 vdd well_1289 sg13_lv_pmos w=1u l=1u m=1
RT1290 vdd well_1290 ntap1 A=4e-12 P=8e-6
MM2_7 dm_1 net1 vdd well_1290 sg13_lv_pmos w=1u l=1u m=1
RT1291 vdd well_1291 ntap1 A=4e-12 P=8e-6
MM2_8 dm_1 net1 vdd well_1291 sg13_lv_pmos w=1u l=1u m=1
RT1292 vdd well_1292 ntap1 A=4e-12 P=8e-6
MM2_9 dm_1 net1 vdd well_1292 sg13_lv_pmos w=1u l=1u m=1
RT1293 vdd well_1293 ntap1 A=4e-12 P=8e-6
MM2_10 dm_1 net1 vdd well_1293 sg13_lv_pmos w=1u l=1u m=1
RT1294 vdd well_1294 ntap1 A=4e-12 P=8e-6
MM2_11 dm_1 net1 vdd well_1294 sg13_lv_pmos w=1u l=1u m=1
RT1295 vdd well_1295 ntap1 A=4e-12 P=8e-6
MM2_12 dm_1 net1 vdd well_1295 sg13_lv_pmos w=1u l=1u m=1
RT1296 vdd well_1296 ntap1 A=4e-12 P=8e-6
MM2_13 dm_1 net1 vdd well_1296 sg13_lv_pmos w=1u l=1u m=1
RT1297 vdd well_1297 ntap1 A=4e-12 P=8e-6
MM2_14 dm_1 net1 vdd well_1297 sg13_lv_pmos w=1u l=1u m=1
RT1298 vdd well_1298 ntap1 A=4e-12 P=8e-6
MM2_15 dm_1 net1 vdd well_1298 sg13_lv_pmos w=1u l=1u m=1
RT1299 vdd well_1299 ntap1 A=4e-12 P=8e-6
MM2_16 dm_1 net1 vdd well_1299 sg13_lv_pmos w=1u l=1u m=1
RT1300 vdd well_1300 ntap1 A=4e-12 P=8e-6
MM2_17 dm_1 net1 vdd well_1300 sg13_lv_pmos w=1u l=1u m=1
RT1301 vdd well_1301 ntap1 A=4e-12 P=8e-6
MM2_18 dm_1 net1 vdd well_1301 sg13_lv_pmos w=1u l=1u m=1
RT1302 vdd well_1302 ntap1 A=4e-12 P=8e-6
MM2_19 dm_1 net1 vdd well_1302 sg13_lv_pmos w=1u l=1u m=1
RT1303 vdd well_1303 ntap1 A=4e-12 P=8e-6
MM2_20 dm_1 net1 vdd well_1303 sg13_lv_pmos w=1u l=1u m=1
RT1304 vdd well_1304 ntap1 A=4e-12 P=8e-6
MM2_21 dm_1 net1 vdd well_1304 sg13_lv_pmos w=1u l=1u m=1
RT1305 vdd well_1305 ntap1 A=4e-12 P=8e-6
MM2_22 dm_1 net1 vdd well_1305 sg13_lv_pmos w=1u l=1u m=1
RT1306 vdd well_1306 ntap1 A=4e-12 P=8e-6
MM2_23 dm_1 net1 vdd well_1306 sg13_lv_pmos w=1u l=1u m=1
RT1307 vdd well_1307 ntap1 A=4e-12 P=8e-6
MM2_24 dm_1 net1 vdd well_1307 sg13_lv_pmos w=1u l=1u m=1
RT1308 vdd well_1308 ntap1 A=4e-12 P=8e-6
MM2_25 dm_1 net1 vdd well_1308 sg13_lv_pmos w=1u l=1u m=1
RT1309 vdd well_1309 ntap1 A=4e-12 P=8e-6
MM2_26 dm_1 net1 vdd well_1309 sg13_lv_pmos w=1u l=1u m=1
RT1310 vdd well_1310 ntap1 A=4e-12 P=8e-6
MM2_27 dm_1 net1 vdd well_1310 sg13_lv_pmos w=1u l=1u m=1
RT1311 vdd well_1311 ntap1 A=4e-12 P=8e-6
MM2_28 dm_1 net1 vdd well_1311 sg13_lv_pmos w=1u l=1u m=1
RT1312 vdd well_1312 ntap1 A=4e-12 P=8e-6
MM2_29 dm_1 net1 vdd well_1312 sg13_lv_pmos w=1u l=1u m=1
RT1313 vdd well_1313 ntap1 A=4e-12 P=8e-6
MM2_30 dm_1 net1 vdd well_1313 sg13_lv_pmos w=1u l=1u m=1
RT1314 vdd well_1314 ntap1 A=4e-12 P=8e-6
MM2_31 dm_1 net1 vdd well_1314 sg13_lv_pmos w=1u l=1u m=1
RT1315 vdd well_1315 ntap1 A=4e-12 P=8e-6
MM2_32 dm_1 net1 vdd well_1315 sg13_lv_pmos w=1u l=1u m=1
RT1316 vdd well_1316 ntap1 A=4e-12 P=8e-6
MM2_33 dm_1 net1 vdd well_1316 sg13_lv_pmos w=1u l=1u m=1
RT1317 vdd well_1317 ntap1 A=4e-12 P=8e-6
MM2_34 dm_1 net1 vdd well_1317 sg13_lv_pmos w=1u l=1u m=1
RT1318 vdd well_1318 ntap1 A=4e-12 P=8e-6
MM2_35 dm_1 net1 vdd well_1318 sg13_lv_pmos w=1u l=1u m=1
RT1319 vdd well_1319 ntap1 A=4e-12 P=8e-6
MM2_36 dm_1 net1 vdd well_1319 sg13_lv_pmos w=1u l=1u m=1
RT1320 vdd well_1320 ntap1 A=4e-12 P=8e-6
MM2_37 dm_1 net1 vdd well_1320 sg13_lv_pmos w=1u l=1u m=1
RT1321 vdd well_1321 ntap1 A=4e-12 P=8e-6
MM2_38 dm_1 net1 vdd well_1321 sg13_lv_pmos w=1u l=1u m=1
RT1322 vdd well_1322 ntap1 A=4e-12 P=8e-6
MM2_39 dm_1 net1 vdd well_1322 sg13_lv_pmos w=1u l=1u m=1
RT1323 vdd well_1323 ntap1 A=4e-12 P=8e-6
MM2_40 dm_1 net1 vdd well_1323 sg13_lv_pmos w=1u l=1u m=1
RT1324 vdd well_1324 ntap1 A=4e-12 P=8e-6
MM2_41 dm_1 net1 vdd well_1324 sg13_lv_pmos w=1u l=1u m=1
RT1325 vdd well_1325 ntap1 A=4e-12 P=8e-6
MM2_42 dm_1 net1 vdd well_1325 sg13_lv_pmos w=1u l=1u m=1
RT1326 vdd well_1326 ntap1 A=4e-12 P=8e-6
MM2_43 dm_1 net1 vdd well_1326 sg13_lv_pmos w=1u l=1u m=1
RT1327 vdd well_1327 ntap1 A=4e-12 P=8e-6
MM2_44 dm_1 net1 vdd well_1327 sg13_lv_pmos w=1u l=1u m=1
RT1328 vdd well_1328 ntap1 A=4e-12 P=8e-6
MM2_45 dm_1 net1 vdd well_1328 sg13_lv_pmos w=1u l=1u m=1
RT1329 vdd well_1329 ntap1 A=4e-12 P=8e-6
MM2_46 dm_1 net1 vdd well_1329 sg13_lv_pmos w=1u l=1u m=1
RT1330 vdd well_1330 ntap1 A=4e-12 P=8e-6
MM2_47 dm_1 net1 vdd well_1330 sg13_lv_pmos w=1u l=1u m=1
RT1331 vdd well_1331 ntap1 A=4e-12 P=8e-6
MM2_48 dm_1 net1 vdd well_1331 sg13_lv_pmos w=1u l=1u m=1
RT1332 vdd well_1332 ntap1 A=4e-12 P=8e-6
MM2_49 dm_1 net1 vdd well_1332 sg13_lv_pmos w=1u l=1u m=1
RT1333 vdd well_1333 ntap1 A=4e-12 P=8e-6
MM2_50 dm_1 net1 vdd well_1333 sg13_lv_pmos w=1u l=1u m=1
RT1334 vdd well_1334 ntap1 A=4e-12 P=8e-6
MM2_51 dm_1 net1 vdd well_1334 sg13_lv_pmos w=1u l=1u m=1
RT1335 vdd well_1335 ntap1 A=4e-12 P=8e-6
MM2_52 dm_1 net1 vdd well_1335 sg13_lv_pmos w=1u l=1u m=1
RT1336 vdd well_1336 ntap1 A=4e-12 P=8e-6
MM2_53 dm_1 net1 vdd well_1336 sg13_lv_pmos w=1u l=1u m=1
RT1337 vdd well_1337 ntap1 A=4e-12 P=8e-6
MM2_54 dm_1 net1 vdd well_1337 sg13_lv_pmos w=1u l=1u m=1
RT1338 vdd well_1338 ntap1 A=4e-12 P=8e-6
MM2_55 dm_1 net1 vdd well_1338 sg13_lv_pmos w=1u l=1u m=1
RT1339 vdd well_1339 ntap1 A=4e-12 P=8e-6
MM2_56 dm_1 net1 vdd well_1339 sg13_lv_pmos w=1u l=1u m=1
RT1340 vdd well_1340 ntap1 A=4e-12 P=8e-6
MM2_57 dm_1 net1 vdd well_1340 sg13_lv_pmos w=1u l=1u m=1
RT1341 vdd well_1341 ntap1 A=4e-12 P=8e-6
MM2_58 dm_1 net1 vdd well_1341 sg13_lv_pmos w=1u l=1u m=1
RT1342 vdd well_1342 ntap1 A=4e-12 P=8e-6
MM2_59 dm_1 net1 vdd well_1342 sg13_lv_pmos w=1u l=1u m=1
RT1343 vdd well_1343 ntap1 A=4e-12 P=8e-6
MM2_60 dm_1 net1 vdd well_1343 sg13_lv_pmos w=1u l=1u m=1
RT1344 vdd well_1344 ntap1 A=4e-12 P=8e-6
MM2_61 dm_1 net1 vdd well_1344 sg13_lv_pmos w=1u l=1u m=1
RT1345 vdd well_1345 ntap1 A=4e-12 P=8e-6
MM2_62 dm_1 net1 vdd well_1345 sg13_lv_pmos w=1u l=1u m=1
RT1346 vdd well_1346 ntap1 A=4e-12 P=8e-6
MM2_63 dm_1 net1 vdd well_1346 sg13_lv_pmos w=1u l=1u m=1
RT1347 vdd well_1347 ntap1 A=4e-12 P=8e-6
MM2_64 dm_1 net1 vdd well_1347 sg13_lv_pmos w=1u l=1u m=1
RT1348 vdd well_1348 ntap1 A=4e-12 P=8e-6
MM2_65 dm_1 net1 vdd well_1348 sg13_lv_pmos w=1u l=1u m=1
RT1349 vdd well_1349 ntap1 A=4e-12 P=8e-6
MM2_66 dm_1 net1 vdd well_1349 sg13_lv_pmos w=1u l=1u m=1
RT1350 vdd well_1350 ntap1 A=4e-12 P=8e-6
MM2_67 dm_1 net1 vdd well_1350 sg13_lv_pmos w=1u l=1u m=1
RT1351 vdd well_1351 ntap1 A=4e-12 P=8e-6
MM2_68 dm_1 net1 vdd well_1351 sg13_lv_pmos w=1u l=1u m=1
RT1352 vdd well_1352 ntap1 A=4e-12 P=8e-6
MM2_69 dm_1 net1 vdd well_1352 sg13_lv_pmos w=1u l=1u m=1
RT1353 vdd well_1353 ntap1 A=4e-12 P=8e-6
MM2_70 dm_1 net1 vdd well_1353 sg13_lv_pmos w=1u l=1u m=1
RT1354 vss sub ptap1 A=4e-12 P=8e-6
MM20_0 net063 vb4 vss sub sg13_lv_nmos w=1u l=1u m=1
RT1355 vss sub ptap1 A=4e-12 P=8e-6
MM20_1 net063 vb4 vss sub sg13_lv_nmos w=1u l=1u m=1
RT1356 vss sub ptap1 A=4e-12 P=8e-6
MM20_2 net063 vb4 vss sub sg13_lv_nmos w=1u l=1u m=1
RT1357 vss sub ptap1 A=4e-12 P=8e-6
MM20_3 net063 vb4 vss sub sg13_lv_nmos w=1u l=1u m=1
RT1358 vss sub ptap1 A=4e-12 P=8e-6
MM20_4 net063 vb4 vss sub sg13_lv_nmos w=1u l=1u m=1
RT1359 vss sub ptap1 A=4e-12 P=8e-6
MM20_5 net063 vb4 vss sub sg13_lv_nmos w=1u l=1u m=1
RT1360 vss sub ptap1 A=4e-12 P=8e-6
MM20_6 net063 vb4 vss sub sg13_lv_nmos w=1u l=1u m=1
RT1361 vss sub ptap1 A=4e-12 P=8e-6
MM20_7 net063 vb4 vss sub sg13_lv_nmos w=1u l=1u m=1
RT1362 vss sub ptap1 A=4e-12 P=8e-6
MM20_8 net063 vb4 vss sub sg13_lv_nmos w=1u l=1u m=1
RT1363 vss sub ptap1 A=4e-12 P=8e-6
MM20_9 net063 vb4 vss sub sg13_lv_nmos w=1u l=1u m=1
RT1364 vss sub ptap1 A=4e-12 P=8e-6
MM20_10 net063 vb4 vss sub sg13_lv_nmos w=1u l=1u m=1
RT1365 vss sub ptap1 A=4e-12 P=8e-6
MM20_11 net063 vb4 vss sub sg13_lv_nmos w=1u l=1u m=1
RT1366 vss sub ptap1 A=4e-12 P=8e-6
MM20_12 net063 vb4 vss sub sg13_lv_nmos w=1u l=1u m=1
RT1367 vss sub ptap1 A=4e-12 P=8e-6
MM20_13 net063 vb4 vss sub sg13_lv_nmos w=1u l=1u m=1
RT1368 vss sub ptap1 A=4e-12 P=8e-6
MM20_14 net063 vb4 vss sub sg13_lv_nmos w=1u l=1u m=1
RT1369 vss sub ptap1 A=4e-12 P=8e-6
MM20_15 net063 vb4 vss sub sg13_lv_nmos w=1u l=1u m=1
RT1370 vss sub ptap1 A=4e-12 P=8e-6
MM20_16 net063 vb4 vss sub sg13_lv_nmos w=1u l=1u m=1
RT1371 vss sub ptap1 A=4e-12 P=8e-6
MM20_17 net063 vb4 vss sub sg13_lv_nmos w=1u l=1u m=1
RT1372 vss sub ptap1 A=4e-12 P=8e-6
MM20_18 net063 vb4 vss sub sg13_lv_nmos w=1u l=1u m=1
RT1373 vss sub ptap1 A=4e-12 P=8e-6
MM20_19 net063 vb4 vss sub sg13_lv_nmos w=1u l=1u m=1
RT1374 vss sub ptap1 A=4e-12 P=8e-6
MM20_20 net063 vb4 vss sub sg13_lv_nmos w=1u l=1u m=1
RT1375 vss sub ptap1 A=4e-12 P=8e-6
MM20_21 net063 vb4 vss sub sg13_lv_nmos w=1u l=1u m=1
RT1376 vss sub ptap1 A=4e-12 P=8e-6
MM20_22 net063 vb4 vss sub sg13_lv_nmos w=1u l=1u m=1
RT1377 vss sub ptap1 A=4e-12 P=8e-6
MM20_23 net063 vb4 vss sub sg13_lv_nmos w=1u l=1u m=1
RT1378 vss sub ptap1 A=4e-12 P=8e-6
MM20_24 net063 vb4 vss sub sg13_lv_nmos w=1u l=1u m=1
RT1379 vss sub ptap1 A=4e-12 P=8e-6
MM20_25 net063 vb4 vss sub sg13_lv_nmos w=1u l=1u m=1
RT1380 vss sub ptap1 A=4e-12 P=8e-6
MM20_26 net063 vb4 vss sub sg13_lv_nmos w=1u l=1u m=1
RT1381 vss sub ptap1 A=4e-12 P=8e-6
MM20_27 net063 vb4 vss sub sg13_lv_nmos w=1u l=1u m=1
RT1382 vss sub ptap1 A=4e-12 P=8e-6
MM20_28 net063 vb4 vss sub sg13_lv_nmos w=1u l=1u m=1
RT1383 vss sub ptap1 A=4e-12 P=8e-6
MM20_29 net063 vb4 vss sub sg13_lv_nmos w=1u l=1u m=1
RT1384 vss sub ptap1 A=4e-12 P=8e-6
MM20_30 net063 vb4 vss sub sg13_lv_nmos w=1u l=1u m=1
RT1385 vss sub ptap1 A=4e-12 P=8e-6
MM20_31 net063 vb4 vss sub sg13_lv_nmos w=1u l=1u m=1
RT1386 vss sub ptap1 A=4e-12 P=8e-6
MM20_32 net063 vb4 vss sub sg13_lv_nmos w=1u l=1u m=1
RT1387 vss sub ptap1 A=4e-12 P=8e-6
MM20_33 net063 vb4 vss sub sg13_lv_nmos w=1u l=1u m=1
RT1388 vss sub ptap1 A=4e-12 P=8e-6
MM20_34 net063 vb4 vss sub sg13_lv_nmos w=1u l=1u m=1
RT1389 vss sub ptap1 A=4e-12 P=8e-6
MM20_35 net063 vb4 vss sub sg13_lv_nmos w=1u l=1u m=1
RT1390 vss sub ptap1 A=4e-12 P=8e-6
MM20_36 net063 vb4 vss sub sg13_lv_nmos w=1u l=1u m=1
RT1391 vss sub ptap1 A=4e-12 P=8e-6
MM20_37 net063 vb4 vss sub sg13_lv_nmos w=1u l=1u m=1
RT1392 vss sub ptap1 A=4e-12 P=8e-6
MM20_38 net063 vb4 vss sub sg13_lv_nmos w=1u l=1u m=1
RT1393 vss sub ptap1 A=4e-12 P=8e-6
MM20_39 net063 vb4 vss sub sg13_lv_nmos w=1u l=1u m=1
RT1394 vss sub ptap1 A=4e-12 P=8e-6
MM20_40 net063 vb4 vss sub sg13_lv_nmos w=1u l=1u m=1
RT1395 vss sub ptap1 A=4e-12 P=8e-6
MM20_41 net063 vb4 vss sub sg13_lv_nmos w=1u l=1u m=1
RT1396 vss sub ptap1 A=4e-12 P=8e-6
MM20_42 net063 vb4 vss sub sg13_lv_nmos w=1u l=1u m=1
RT1397 vss sub ptap1 A=4e-12 P=8e-6
MM20_43 net063 vb4 vss sub sg13_lv_nmos w=1u l=1u m=1
RT1398 vss sub ptap1 A=4e-12 P=8e-6
MM20_44 net063 vb4 vss sub sg13_lv_nmos w=1u l=1u m=1
RT1399 vss sub ptap1 A=4e-12 P=8e-6
MM20_45 net063 vb4 vss sub sg13_lv_nmos w=1u l=1u m=1
RT1400 vss sub ptap1 A=4e-12 P=8e-6
MM20_46 net063 vb4 vss sub sg13_lv_nmos w=1u l=1u m=1
RT1401 vss sub ptap1 A=4e-12 P=8e-6
MM20_47 net063 vb4 vss sub sg13_lv_nmos w=1u l=1u m=1
RT1402 vss sub ptap1 A=4e-12 P=8e-6
MM20_48 net063 vb4 vss sub sg13_lv_nmos w=1u l=1u m=1
RT1403 vss sub ptap1 A=4e-12 P=8e-6
MM20_49 net063 vb4 vss sub sg13_lv_nmos w=1u l=1u m=1
RT1404 vss sub ptap1 A=4e-12 P=8e-6
MM20_50 net063 vb4 vss sub sg13_lv_nmos w=1u l=1u m=1
RT1405 vss sub ptap1 A=4e-12 P=8e-6
MM20_51 net063 vb4 vss sub sg13_lv_nmos w=1u l=1u m=1
RT1406 vss sub ptap1 A=4e-12 P=8e-6
MM20_52 net063 vb4 vss sub sg13_lv_nmos w=1u l=1u m=1
RT1407 vss sub ptap1 A=4e-12 P=8e-6
MM20_53 net063 vb4 vss sub sg13_lv_nmos w=1u l=1u m=1
RT1408 vss sub ptap1 A=4e-12 P=8e-6
MM20_54 net063 vb4 vss sub sg13_lv_nmos w=1u l=1u m=1
RT1409 vss sub ptap1 A=4e-12 P=8e-6
MM20_55 net063 vb4 vss sub sg13_lv_nmos w=1u l=1u m=1
RT1410 vss sub ptap1 A=4e-12 P=8e-6
MM20_56 net063 vb4 vss sub sg13_lv_nmos w=1u l=1u m=1
RT1411 vss sub ptap1 A=4e-12 P=8e-6
MM20_57 net063 vb4 vss sub sg13_lv_nmos w=1u l=1u m=1
RT1412 vss sub ptap1 A=4e-12 P=8e-6
MM20_58 net063 vb4 vss sub sg13_lv_nmos w=1u l=1u m=1
RT1413 vss sub ptap1 A=4e-12 P=8e-6
MM20_59 net063 vb4 vss sub sg13_lv_nmos w=1u l=1u m=1
RT1414 vss sub ptap1 A=4e-12 P=8e-6
MM20_60 net063 vb4 vss sub sg13_lv_nmos w=1u l=1u m=1
RT1415 vss sub ptap1 A=4e-12 P=8e-6
MM20_61 net063 vb4 vss sub sg13_lv_nmos w=1u l=1u m=1
RT1416 vss sub ptap1 A=4e-12 P=8e-6
MM20_62 net063 vb4 vss sub sg13_lv_nmos w=1u l=1u m=1
RT1417 vss sub ptap1 A=4e-12 P=8e-6
MM20_63 net063 vb4 vss sub sg13_lv_nmos w=1u l=1u m=1
RT1418 vss sub ptap1 A=4e-12 P=8e-6
MM20_64 net063 vb4 vss sub sg13_lv_nmos w=1u l=1u m=1
RT1419 vss sub ptap1 A=4e-12 P=8e-6
MM20_65 net063 vb4 vss sub sg13_lv_nmos w=1u l=1u m=1
RT1420 vss sub ptap1 A=4e-12 P=8e-6
MM20_66 net063 vb4 vss sub sg13_lv_nmos w=1u l=1u m=1
RT1421 vss sub ptap1 A=4e-12 P=8e-6
MM20_67 net063 vb4 vss sub sg13_lv_nmos w=1u l=1u m=1
RT1422 vss sub ptap1 A=4e-12 P=8e-6
MM20_68 net063 vb4 vss sub sg13_lv_nmos w=1u l=1u m=1
RT1423 vss sub ptap1 A=4e-12 P=8e-6
MM20_69 net063 vb4 vss sub sg13_lv_nmos w=1u l=1u m=1
RT1424 vss sub ptap1 A=4e-12 P=8e-6
MM20_70 net063 vb4 vss sub sg13_lv_nmos w=1u l=1u m=1
RT1425 vss sub ptap1 A=4e-12 P=8e-6
MM20_71 net063 vb4 vss sub sg13_lv_nmos w=1u l=1u m=1
RT1426 vss sub ptap1 A=4e-12 P=8e-6
MM20_72 net063 vb4 vss sub sg13_lv_nmos w=1u l=1u m=1
RT1427 vss sub ptap1 A=4e-12 P=8e-6
MM20_73 net063 vb4 vss sub sg13_lv_nmos w=1u l=1u m=1
RT1428 vss sub ptap1 A=4e-12 P=8e-6
MM20_74 net063 vb4 vss sub sg13_lv_nmos w=1u l=1u m=1
RT1429 vss sub ptap1 A=4e-12 P=8e-6
MM20_75 net063 vb4 vss sub sg13_lv_nmos w=1u l=1u m=1
RT1430 vss sub ptap1 A=4e-12 P=8e-6
MM20_76 net063 vb4 vss sub sg13_lv_nmos w=1u l=1u m=1
RT1431 vss sub ptap1 A=4e-12 P=8e-6
MM20_77 net063 vb4 vss sub sg13_lv_nmos w=1u l=1u m=1
RT1432 vss sub ptap1 A=4e-12 P=8e-6
MM20_78 net063 vb4 vss sub sg13_lv_nmos w=1u l=1u m=1
RT1433 vss sub ptap1 A=4e-12 P=8e-6
MM20_79 net063 vb4 vss sub sg13_lv_nmos w=1u l=1u m=1
RT1434 vss sub ptap1 A=4e-12 P=8e-6
MM20_80 net063 vb4 vss sub sg13_lv_nmos w=1u l=1u m=1
RT1435 vss sub ptap1 A=4e-12 P=8e-6
MM20_81 net063 vb4 vss sub sg13_lv_nmos w=1u l=1u m=1
RT1436 vss sub ptap1 A=4e-12 P=8e-6
MM20_82 net063 vb4 vss sub sg13_lv_nmos w=1u l=1u m=1
RT1437 vss sub ptap1 A=4e-12 P=8e-6
MM20_83 net063 vb4 vss sub sg13_lv_nmos w=1u l=1u m=1
RT1438 vss sub ptap1 A=4e-12 P=8e-6
MM20_84 net063 vb4 vss sub sg13_lv_nmos w=1u l=1u m=1
RT1439 vss sub ptap1 A=4e-12 P=8e-6
MM20_85 net063 vb4 vss sub sg13_lv_nmos w=1u l=1u m=1
RT1440 vss sub ptap1 A=4e-12 P=8e-6
MM20_86 net063 vb4 vss sub sg13_lv_nmos w=1u l=1u m=1
RT1441 vss sub ptap1 A=4e-12 P=8e-6
MM20_87 net063 vb4 vss sub sg13_lv_nmos w=1u l=1u m=1
RT1442 vss sub ptap1 A=4e-12 P=8e-6
MM20_88 net063 vb4 vss sub sg13_lv_nmos w=1u l=1u m=1
RT1443 vss sub ptap1 A=4e-12 P=8e-6
MM20_89 net063 vb4 vss sub sg13_lv_nmos w=1u l=1u m=1
RT1444 vss sub ptap1 A=4e-12 P=8e-6
MM20_90 net063 vb4 vss sub sg13_lv_nmos w=1u l=1u m=1
RT1445 vss sub ptap1 A=4e-12 P=8e-6
MM20_91 net063 vb4 vss sub sg13_lv_nmos w=1u l=1u m=1
RT1446 vss sub ptap1 A=4e-12 P=8e-6
MM20_92 net063 vb4 vss sub sg13_lv_nmos w=1u l=1u m=1
RT1447 vss sub ptap1 A=4e-12 P=8e-6
MM20_93 net063 vb4 vss sub sg13_lv_nmos w=1u l=1u m=1
RT1448 vss sub ptap1 A=4e-12 P=8e-6
MM20_94 net063 vb4 vss sub sg13_lv_nmos w=1u l=1u m=1
RT1449 vss sub ptap1 A=4e-12 P=8e-6
MM20_95 net063 vb4 vss sub sg13_lv_nmos w=1u l=1u m=1
RT1450 vss sub ptap1 A=4e-12 P=8e-6
MM20_96 net063 vb4 vss sub sg13_lv_nmos w=1u l=1u m=1
RT1451 vss sub ptap1 A=4e-12 P=8e-6
MM20_97 net063 vb4 vss sub sg13_lv_nmos w=1u l=1u m=1
RT1452 vss sub ptap1 A=4e-12 P=8e-6
MM20_98 net063 vb4 vss sub sg13_lv_nmos w=1u l=1u m=1
RT1453 vss sub ptap1 A=4e-12 P=8e-6
MM20_99 net063 vb4 vss sub sg13_lv_nmos w=1u l=1u m=1
RT1454 vss sub ptap1 A=4e-12 P=8e-6
MM20_100 net063 vb4 vss sub sg13_lv_nmos w=1u l=1u m=1
RT1455 vss sub ptap1 A=4e-12 P=8e-6
MM20_101 net063 vb4 vss sub sg13_lv_nmos w=1u l=1u m=1
RT1456 vss sub ptap1 A=4e-12 P=8e-6
MM20_102 net063 vb4 vss sub sg13_lv_nmos w=1u l=1u m=1
RT1457 vss sub ptap1 A=4e-12 P=8e-6
MM20_103 net063 vb4 vss sub sg13_lv_nmos w=1u l=1u m=1
RT1458 vss sub ptap1 A=4e-12 P=8e-6
MM20_104 net063 vb4 vss sub sg13_lv_nmos w=1u l=1u m=1
RT1459 vss sub ptap1 A=4e-12 P=8e-6
MM20_105 net063 vb4 vss sub sg13_lv_nmos w=1u l=1u m=1
RT1460 vss sub ptap1 A=4e-12 P=8e-6
MM20_106 net063 vb4 vss sub sg13_lv_nmos w=1u l=1u m=1
RT1461 vss sub ptap1 A=4e-12 P=8e-6
MM20_107 net063 vb4 vss sub sg13_lv_nmos w=1u l=1u m=1
RT1462 vss sub ptap1 A=4e-12 P=8e-6
MM20_108 net063 vb4 vss sub sg13_lv_nmos w=1u l=1u m=1
RT1463 vss sub ptap1 A=4e-12 P=8e-6
MM20_109 net063 vb4 vss sub sg13_lv_nmos w=1u l=1u m=1
RT1464 vss sub ptap1 A=4e-12 P=8e-6
MM20_110 net063 vb4 vss sub sg13_lv_nmos w=1u l=1u m=1
RT1465 vss sub ptap1 A=4e-12 P=8e-6
MM20_111 net063 vb4 vss sub sg13_lv_nmos w=1u l=1u m=1
RT1466 vss sub ptap1 A=4e-12 P=8e-6
MM20_112 net063 vb4 vss sub sg13_lv_nmos w=1u l=1u m=1
RT1467 vss sub ptap1 A=4e-12 P=8e-6
MM20_113 net063 vb4 vss sub sg13_lv_nmos w=1u l=1u m=1
RT1468 vss sub ptap1 A=4e-12 P=8e-6
MM20_114 net063 vb4 vss sub sg13_lv_nmos w=1u l=1u m=1
RT1469 vss sub ptap1 A=4e-12 P=8e-6
MM20_115 net063 vb4 vss sub sg13_lv_nmos w=1u l=1u m=1
RT1470 vss sub ptap1 A=4e-12 P=8e-6
MM20_116 net063 vb4 vss sub sg13_lv_nmos w=1u l=1u m=1
RT1471 vss sub ptap1 A=4e-12 P=8e-6
MM20_117 net063 vb4 vss sub sg13_lv_nmos w=1u l=1u m=1
RT1472 vss sub ptap1 A=4e-12 P=8e-6
MM20_118 net063 vb4 vss sub sg13_lv_nmos w=1u l=1u m=1
RT1473 vss sub ptap1 A=4e-12 P=8e-6
MM20_119 net063 vb4 vss sub sg13_lv_nmos w=1u l=1u m=1
RT1474 vss sub ptap1 A=4e-12 P=8e-6
MM20_120 net063 vb4 vss sub sg13_lv_nmos w=1u l=1u m=1
RT1475 vss sub ptap1 A=4e-12 P=8e-6
MM20_121 net063 vb4 vss sub sg13_lv_nmos w=1u l=1u m=1
RT1476 vss sub ptap1 A=4e-12 P=8e-6
MM20_122 net063 vb4 vss sub sg13_lv_nmos w=1u l=1u m=1
RT1477 vss sub ptap1 A=4e-12 P=8e-6
MM20_123 net063 vb4 vss sub sg13_lv_nmos w=1u l=1u m=1
RT1478 vss sub ptap1 A=4e-12 P=8e-6
MM20_124 net063 vb4 vss sub sg13_lv_nmos w=1u l=1u m=1
RT1479 vss sub ptap1 A=4e-12 P=8e-6
MM20_125 net063 vb4 vss sub sg13_lv_nmos w=1u l=1u m=1
RT1480 vss sub ptap1 A=4e-12 P=8e-6
MM20_126 net063 vb4 vss sub sg13_lv_nmos w=1u l=1u m=1
RT1481 vss sub ptap1 A=4e-12 P=8e-6
MM20_127 net063 vb4 vss sub sg13_lv_nmos w=1u l=1u m=1
RT1482 vss sub ptap1 A=4e-12 P=8e-6
MM20_128 net063 vb4 vss sub sg13_lv_nmos w=1u l=1u m=1
RT1483 vss sub ptap1 A=4e-12 P=8e-6
MM20_129 net063 vb4 vss sub sg13_lv_nmos w=1u l=1u m=1
RT1484 vss sub ptap1 A=4e-12 P=8e-6
MM20_130 net063 vb4 vss sub sg13_lv_nmos w=1u l=1u m=1
RT1485 vss sub ptap1 A=4e-12 P=8e-6
MM20_131 net063 vb4 vss sub sg13_lv_nmos w=1u l=1u m=1
RT1486 vss sub ptap1 A=4e-12 P=8e-6
MM20_132 net063 vb4 vss sub sg13_lv_nmos w=1u l=1u m=1
RT1487 vss sub ptap1 A=4e-12 P=8e-6
MM20_133 net063 vb4 vss sub sg13_lv_nmos w=1u l=1u m=1
RT1488 vss sub ptap1 A=4e-12 P=8e-6
MM20_134 net063 vb4 vss sub sg13_lv_nmos w=1u l=1u m=1
RT1489 vss sub ptap1 A=4e-12 P=8e-6
MM20_135 net063 vb4 vss sub sg13_lv_nmos w=1u l=1u m=1
RT1490 vss sub ptap1 A=4e-12 P=8e-6
MM20_136 net063 vb4 vss sub sg13_lv_nmos w=1u l=1u m=1
RT1491 vss sub ptap1 A=4e-12 P=8e-6
MM20_137 net063 vb4 vss sub sg13_lv_nmos w=1u l=1u m=1
RT1492 vss sub ptap1 A=4e-12 P=8e-6
MM20_138 net063 vb4 vss sub sg13_lv_nmos w=1u l=1u m=1
RT1493 vss sub ptap1 A=4e-12 P=8e-6
MM20_139 net063 vb4 vss sub sg13_lv_nmos w=1u l=1u m=1
RT1494 vss sub ptap1 A=4e-12 P=8e-6
MM20_140 net063 vb4 vss sub sg13_lv_nmos w=1u l=1u m=1
RT1495 vss sub ptap1 A=4e-12 P=8e-6
MM20_141 net063 vb4 vss sub sg13_lv_nmos w=1u l=1u m=1
RT1496 vss sub ptap1 A=4e-12 P=8e-6
MM20_142 net063 vb4 vss sub sg13_lv_nmos w=1u l=1u m=1
RT1497 vss sub ptap1 A=4e-12 P=8e-6
MM20_143 net063 vb4 vss sub sg13_lv_nmos w=1u l=1u m=1
RT1498 vss sub ptap1 A=4e-12 P=8e-6
MM20_144 net063 vb4 vss sub sg13_lv_nmos w=1u l=1u m=1
RT1499 vss sub ptap1 A=4e-12 P=8e-6
MM20_145 net063 vb4 vss sub sg13_lv_nmos w=1u l=1u m=1
RT1500 vss sub ptap1 A=4e-12 P=8e-6
MM20_146 net063 vb4 vss sub sg13_lv_nmos w=1u l=1u m=1
RT1501 vss sub ptap1 A=4e-12 P=8e-6
MM20_147 net063 vb4 vss sub sg13_lv_nmos w=1u l=1u m=1
RT1502 vss sub ptap1 A=4e-12 P=8e-6
MM20_148 net063 vb4 vss sub sg13_lv_nmos w=1u l=1u m=1
RT1503 vss sub ptap1 A=4e-12 P=8e-6
MM20_149 net063 vb4 vss sub sg13_lv_nmos w=1u l=1u m=1
RT1504 vss sub ptap1 A=4e-12 P=8e-6
MM20_150 net063 vb4 vss sub sg13_lv_nmos w=1u l=1u m=1
RT1505 vss sub ptap1 A=4e-12 P=8e-6
MM20_151 net063 vb4 vss sub sg13_lv_nmos w=1u l=1u m=1
RT1506 vss sub ptap1 A=4e-12 P=8e-6
MM20_152 net063 vb4 vss sub sg13_lv_nmos w=1u l=1u m=1
RT1507 vss sub ptap1 A=4e-12 P=8e-6
MM20_153 net063 vb4 vss sub sg13_lv_nmos w=1u l=1u m=1
RT1508 vss sub ptap1 A=4e-12 P=8e-6
MM20_154 net063 vb4 vss sub sg13_lv_nmos w=1u l=1u m=1
RT1509 vss sub ptap1 A=4e-12 P=8e-6
MM20_155 net063 vb4 vss sub sg13_lv_nmos w=1u l=1u m=1
RT1510 vss sub ptap1 A=4e-12 P=8e-6
MM20_156 net063 vb4 vss sub sg13_lv_nmos w=1u l=1u m=1
RT1511 vss sub ptap1 A=4e-12 P=8e-6
MM20_157 net063 vb4 vss sub sg13_lv_nmos w=1u l=1u m=1
RT1512 vss sub ptap1 A=4e-12 P=8e-6
MM20_158 net063 vb4 vss sub sg13_lv_nmos w=1u l=1u m=1
RT1513 vss sub ptap1 A=4e-12 P=8e-6
MM20_159 net063 vb4 vss sub sg13_lv_nmos w=1u l=1u m=1
RT1514 vss sub ptap1 A=4e-12 P=8e-6
MM21 net043 net043 vss sub sg13_lv_nmos w=1u l=1u m=1
RT1515 vss sub ptap1 A=4e-12 P=8e-6
MM22 net049 net043 vss sub sg13_lv_nmos w=1u l=1u m=1
RT1516 vss sub ptap1 A=4e-12 P=8e-6
MM23_0 vout net049 vss sub sg13_lv_nmos w=1u l=1u m=1
RT1517 vss sub ptap1 A=4e-12 P=8e-6
MM23_1 vout net049 vss sub sg13_lv_nmos w=1u l=1u m=1
RT1518 vss sub ptap1 A=4e-12 P=8e-6
MM23_2 vout net049 vss sub sg13_lv_nmos w=1u l=1u m=1
RT1519 vss sub ptap1 A=4e-12 P=8e-6
MM23_3 vout net049 vss sub sg13_lv_nmos w=1u l=1u m=1
RT1520 vss sub ptap1 A=4e-12 P=8e-6
MM23_4 vout net049 vss sub sg13_lv_nmos w=1u l=1u m=1
RT1521 vss sub ptap1 A=4e-12 P=8e-6
MM23_5 vout net049 vss sub sg13_lv_nmos w=1u l=1u m=1
RT1522 vss sub ptap1 A=4e-12 P=8e-6
MM23_6 vout net049 vss sub sg13_lv_nmos w=1u l=1u m=1
RT1523 vss sub ptap1 A=4e-12 P=8e-6
MM23_7 vout net049 vss sub sg13_lv_nmos w=1u l=1u m=1
RT1524 vss sub ptap1 A=4e-12 P=8e-6
MM23_8 vout net049 vss sub sg13_lv_nmos w=1u l=1u m=1
RT1525 vss sub ptap1 A=4e-12 P=8e-6
MM23_9 vout net049 vss sub sg13_lv_nmos w=1u l=1u m=1
RT1526 vss sub ptap1 A=4e-12 P=8e-6
MM23_10 vout net049 vss sub sg13_lv_nmos w=1u l=1u m=1
RT1527 vss sub ptap1 A=4e-12 P=8e-6
MM23_11 vout net049 vss sub sg13_lv_nmos w=1u l=1u m=1
RT1528 vss sub ptap1 A=4e-12 P=8e-6
MM23_12 vout net049 vss sub sg13_lv_nmos w=1u l=1u m=1
RT1529 vss sub ptap1 A=4e-12 P=8e-6
MM23_13 vout net049 vss sub sg13_lv_nmos w=1u l=1u m=1
RT1530 vss sub ptap1 A=4e-12 P=8e-6
MM23_14 vout net049 vss sub sg13_lv_nmos w=1u l=1u m=1
RT1531 vss sub ptap1 A=4e-12 P=8e-6
MM23_15 vout net049 vss sub sg13_lv_nmos w=1u l=1u m=1
RT1532 vss sub ptap1 A=4e-12 P=8e-6
MM23_16 vout net049 vss sub sg13_lv_nmos w=1u l=1u m=1
RT1533 vss sub ptap1 A=4e-12 P=8e-6
MM23_17 vout net049 vss sub sg13_lv_nmos w=1u l=1u m=1
RT1534 vss sub ptap1 A=4e-12 P=8e-6
MM23_18 vout net049 vss sub sg13_lv_nmos w=1u l=1u m=1
RT1535 vss sub ptap1 A=4e-12 P=8e-6
MM23_19 vout net049 vss sub sg13_lv_nmos w=1u l=1u m=1
RT1536 vss sub ptap1 A=4e-12 P=8e-6
MM23_20 vout net049 vss sub sg13_lv_nmos w=1u l=1u m=1
RT1537 vss sub ptap1 A=4e-12 P=8e-6
MM23_21 vout net049 vss sub sg13_lv_nmos w=1u l=1u m=1
RT1538 vss sub ptap1 A=4e-12 P=8e-6
MM23_22 vout net049 vss sub sg13_lv_nmos w=1u l=1u m=1
RT1539 vss sub ptap1 A=4e-12 P=8e-6
MM23_23 vout net049 vss sub sg13_lv_nmos w=1u l=1u m=1
RT1540 vss sub ptap1 A=4e-12 P=8e-6
MM23_24 vout net049 vss sub sg13_lv_nmos w=1u l=1u m=1
RT1541 vss sub ptap1 A=4e-12 P=8e-6
MM23_25 vout net049 vss sub sg13_lv_nmos w=1u l=1u m=1
RT1542 vss sub ptap1 A=4e-12 P=8e-6
MM23_26 vout net049 vss sub sg13_lv_nmos w=1u l=1u m=1
RT1543 vss sub ptap1 A=4e-12 P=8e-6
MM23_27 vout net049 vss sub sg13_lv_nmos w=1u l=1u m=1
RT1544 vss sub ptap1 A=4e-12 P=8e-6
MM23_28 vout net049 vss sub sg13_lv_nmos w=1u l=1u m=1
RT1545 vss sub ptap1 A=4e-12 P=8e-6
MM23_29 vout net049 vss sub sg13_lv_nmos w=1u l=1u m=1
RT1546 vss sub ptap1 A=4e-12 P=8e-6
MM23_30 vout net049 vss sub sg13_lv_nmos w=1u l=1u m=1
RT1547 vss sub ptap1 A=4e-12 P=8e-6
MM23_31 vout net049 vss sub sg13_lv_nmos w=1u l=1u m=1
RT1548 vss sub ptap1 A=4e-12 P=8e-6
MM23_32 vout net049 vss sub sg13_lv_nmos w=1u l=1u m=1
RT1549 vss sub ptap1 A=4e-12 P=8e-6
MM23_33 vout net049 vss sub sg13_lv_nmos w=1u l=1u m=1
RT1550 vss sub ptap1 A=4e-12 P=8e-6
MM23_34 vout net049 vss sub sg13_lv_nmos w=1u l=1u m=1
RT1551 vss sub ptap1 A=4e-12 P=8e-6
MM23_35 vout net049 vss sub sg13_lv_nmos w=1u l=1u m=1
RT1552 vss sub ptap1 A=4e-12 P=8e-6
MM23_36 vout net049 vss sub sg13_lv_nmos w=1u l=1u m=1
RT1553 vss sub ptap1 A=4e-12 P=8e-6
MM23_37 vout net049 vss sub sg13_lv_nmos w=1u l=1u m=1
RT1554 vss sub ptap1 A=4e-12 P=8e-6
MM23_38 vout net049 vss sub sg13_lv_nmos w=1u l=1u m=1
RT1555 vss sub ptap1 A=4e-12 P=8e-6
MM23_39 vout net049 vss sub sg13_lv_nmos w=1u l=1u m=1
RT1556 vss sub ptap1 A=4e-12 P=8e-6
MM23_40 vout net049 vss sub sg13_lv_nmos w=1u l=1u m=1
RT1557 vss sub ptap1 A=4e-12 P=8e-6
MM23_41 vout net049 vss sub sg13_lv_nmos w=1u l=1u m=1
RT1558 vss sub ptap1 A=4e-12 P=8e-6
MM23_42 vout net049 vss sub sg13_lv_nmos w=1u l=1u m=1
RT1559 vss sub ptap1 A=4e-12 P=8e-6
MM23_43 vout net049 vss sub sg13_lv_nmos w=1u l=1u m=1
RT1560 vss sub ptap1 A=4e-12 P=8e-6
MM23_44 vout net049 vss sub sg13_lv_nmos w=1u l=1u m=1
RT1561 vss sub ptap1 A=4e-12 P=8e-6
MM23_45 vout net049 vss sub sg13_lv_nmos w=1u l=1u m=1
RT1562 vss sub ptap1 A=4e-12 P=8e-6
MM23_46 vout net049 vss sub sg13_lv_nmos w=1u l=1u m=1
RT1563 vss sub ptap1 A=4e-12 P=8e-6
MM23_47 vout net049 vss sub sg13_lv_nmos w=1u l=1u m=1
RT1564 vss sub ptap1 A=4e-12 P=8e-6
MM23_48 vout net049 vss sub sg13_lv_nmos w=1u l=1u m=1
RT1565 vss sub ptap1 A=4e-12 P=8e-6
MM23_49 vout net049 vss sub sg13_lv_nmos w=1u l=1u m=1
RT1566 vss sub ptap1 A=4e-12 P=8e-6
MM23_50 vout net049 vss sub sg13_lv_nmos w=1u l=1u m=1
RT1567 vss sub ptap1 A=4e-12 P=8e-6
MM23_51 vout net049 vss sub sg13_lv_nmos w=1u l=1u m=1
RT1568 vss sub ptap1 A=4e-12 P=8e-6
MM23_52 vout net049 vss sub sg13_lv_nmos w=1u l=1u m=1
RT1569 vss sub ptap1 A=4e-12 P=8e-6
MM23_53 vout net049 vss sub sg13_lv_nmos w=1u l=1u m=1
RT1570 vss sub ptap1 A=4e-12 P=8e-6
MM23_54 vout net049 vss sub sg13_lv_nmos w=1u l=1u m=1
RT1571 vss sub ptap1 A=4e-12 P=8e-6
MM23_55 vout net049 vss sub sg13_lv_nmos w=1u l=1u m=1
RT1572 vss sub ptap1 A=4e-12 P=8e-6
MM23_56 vout net049 vss sub sg13_lv_nmos w=1u l=1u m=1
RT1573 vss sub ptap1 A=4e-12 P=8e-6
MM23_57 vout net049 vss sub sg13_lv_nmos w=1u l=1u m=1
RT1574 vss sub ptap1 A=4e-12 P=8e-6
MM23_58 vout net049 vss sub sg13_lv_nmos w=1u l=1u m=1
RT1575 vss sub ptap1 A=4e-12 P=8e-6
MM23_59 vout net049 vss sub sg13_lv_nmos w=1u l=1u m=1
RT1576 vss sub ptap1 A=4e-12 P=8e-6
MM23_60 vout net049 vss sub sg13_lv_nmos w=1u l=1u m=1
RT1577 vss sub ptap1 A=4e-12 P=8e-6
MM23_61 vout net049 vss sub sg13_lv_nmos w=1u l=1u m=1
RT1578 vss sub ptap1 A=4e-12 P=8e-6
MM23_62 vout net049 vss sub sg13_lv_nmos w=1u l=1u m=1
RT1579 vss sub ptap1 A=4e-12 P=8e-6
MM23_63 vout net049 vss sub sg13_lv_nmos w=1u l=1u m=1
RT1580 vss sub ptap1 A=4e-12 P=8e-6
MM23_64 vout net049 vss sub sg13_lv_nmos w=1u l=1u m=1
RT1581 vss sub ptap1 A=4e-12 P=8e-6
MM23_65 vout net049 vss sub sg13_lv_nmos w=1u l=1u m=1
RT1582 vss sub ptap1 A=4e-12 P=8e-6
MM23_66 vout net049 vss sub sg13_lv_nmos w=1u l=1u m=1
RT1583 vss sub ptap1 A=4e-12 P=8e-6
MM23_67 vout net049 vss sub sg13_lv_nmos w=1u l=1u m=1
RT1584 vss sub ptap1 A=4e-12 P=8e-6
MM23_68 vout net049 vss sub sg13_lv_nmos w=1u l=1u m=1
RT1585 vss sub ptap1 A=4e-12 P=8e-6
MM23_69 vout net049 vss sub sg13_lv_nmos w=1u l=1u m=1
RT1586 vss sub ptap1 A=4e-12 P=8e-6
MM23_70 vout net049 vss sub sg13_lv_nmos w=1u l=1u m=1
RT1587 vss sub ptap1 A=4e-12 P=8e-6
MM23_71 vout net049 vss sub sg13_lv_nmos w=1u l=1u m=1
RT1588 vss sub ptap1 A=4e-12 P=8e-6
MM23_72 vout net049 vss sub sg13_lv_nmos w=1u l=1u m=1
RT1589 vss sub ptap1 A=4e-12 P=8e-6
MM23_73 vout net049 vss sub sg13_lv_nmos w=1u l=1u m=1
RT1590 vss sub ptap1 A=4e-12 P=8e-6
MM23_74 vout net049 vss sub sg13_lv_nmos w=1u l=1u m=1
RT1591 vss sub ptap1 A=4e-12 P=8e-6
MM23_75 vout net049 vss sub sg13_lv_nmos w=1u l=1u m=1
RT1592 vss sub ptap1 A=4e-12 P=8e-6
MM23_76 vout net049 vss sub sg13_lv_nmos w=1u l=1u m=1
RT1593 vss sub ptap1 A=4e-12 P=8e-6
MM23_77 vout net049 vss sub sg13_lv_nmos w=1u l=1u m=1
RT1594 vss sub ptap1 A=4e-12 P=8e-6
MM23_78 vout net049 vss sub sg13_lv_nmos w=1u l=1u m=1
RT1595 vss sub ptap1 A=4e-12 P=8e-6
MM23_79 vout net049 vss sub sg13_lv_nmos w=1u l=1u m=1
RT1596 vss sub ptap1 A=4e-12 P=8e-6
MM23_80 vout net049 vss sub sg13_lv_nmos w=1u l=1u m=1
RT1597 vss sub ptap1 A=4e-12 P=8e-6
MM23_81 vout net049 vss sub sg13_lv_nmos w=1u l=1u m=1
RT1598 vss sub ptap1 A=4e-12 P=8e-6
MM23_82 vout net049 vss sub sg13_lv_nmos w=1u l=1u m=1
RT1599 vss sub ptap1 A=4e-12 P=8e-6
MM23_83 vout net049 vss sub sg13_lv_nmos w=1u l=1u m=1
RT1600 vss sub ptap1 A=4e-12 P=8e-6
MM23_84 vout net049 vss sub sg13_lv_nmos w=1u l=1u m=1
RT1601 vss sub ptap1 A=4e-12 P=8e-6
MM23_85 vout net049 vss sub sg13_lv_nmos w=1u l=1u m=1
RT1602 vss sub ptap1 A=4e-12 P=8e-6
MM23_86 vout net049 vss sub sg13_lv_nmos w=1u l=1u m=1
RT1603 vss sub ptap1 A=4e-12 P=8e-6
MM23_87 vout net049 vss sub sg13_lv_nmos w=1u l=1u m=1
RT1604 vss sub ptap1 A=4e-12 P=8e-6
MM23_88 vout net049 vss sub sg13_lv_nmos w=1u l=1u m=1
RT1605 vss sub ptap1 A=4e-12 P=8e-6
MM23_89 vout net049 vss sub sg13_lv_nmos w=1u l=1u m=1
RT1606 vss sub ptap1 A=4e-12 P=8e-6
MM23_90 vout net049 vss sub sg13_lv_nmos w=1u l=1u m=1
RT1607 vss sub ptap1 A=4e-12 P=8e-6
MM23_91 vout net049 vss sub sg13_lv_nmos w=1u l=1u m=1
RT1608 vss sub ptap1 A=4e-12 P=8e-6
MM23_92 vout net049 vss sub sg13_lv_nmos w=1u l=1u m=1
RT1609 vss sub ptap1 A=4e-12 P=8e-6
MM23_93 vout net049 vss sub sg13_lv_nmos w=1u l=1u m=1
RT1610 vss sub ptap1 A=4e-12 P=8e-6
MM23_94 vout net049 vss sub sg13_lv_nmos w=1u l=1u m=1
RT1611 vss sub ptap1 A=4e-12 P=8e-6
MM23_95 vout net049 vss sub sg13_lv_nmos w=1u l=1u m=1
RT1612 vss sub ptap1 A=4e-12 P=8e-6
MM23_96 vout net049 vss sub sg13_lv_nmos w=1u l=1u m=1
RT1613 vss sub ptap1 A=4e-12 P=8e-6
MM23_97 vout net049 vss sub sg13_lv_nmos w=1u l=1u m=1
RT1614 vss sub ptap1 A=4e-12 P=8e-6
MM23_98 vout net049 vss sub sg13_lv_nmos w=1u l=1u m=1
RT1615 vss sub ptap1 A=4e-12 P=8e-6
MM23_99 vout net049 vss sub sg13_lv_nmos w=1u l=1u m=1
RT1616 vss sub ptap1 A=4e-12 P=8e-6
MM23_100 vout net049 vss sub sg13_lv_nmos w=1u l=1u m=1
RT1617 vss sub ptap1 A=4e-12 P=8e-6
MM23_101 vout net049 vss sub sg13_lv_nmos w=1u l=1u m=1
RT1618 vss sub ptap1 A=4e-12 P=8e-6
MM23_102 vout net049 vss sub sg13_lv_nmos w=1u l=1u m=1
RT1619 vss sub ptap1 A=4e-12 P=8e-6
MM23_103 vout net049 vss sub sg13_lv_nmos w=1u l=1u m=1
RT1620 vss sub ptap1 A=4e-12 P=8e-6
MM23_104 vout net049 vss sub sg13_lv_nmos w=1u l=1u m=1
RT1621 vss sub ptap1 A=4e-12 P=8e-6
MM23_105 vout net049 vss sub sg13_lv_nmos w=1u l=1u m=1
RT1622 vss sub ptap1 A=4e-12 P=8e-6
MM23_106 vout net049 vss sub sg13_lv_nmos w=1u l=1u m=1
RT1623 vss sub ptap1 A=4e-12 P=8e-6
MM23_107 vout net049 vss sub sg13_lv_nmos w=1u l=1u m=1
RT1624 vss sub ptap1 A=4e-12 P=8e-6
MM23_108 vout net049 vss sub sg13_lv_nmos w=1u l=1u m=1
RT1625 vss sub ptap1 A=4e-12 P=8e-6
MM23_109 vout net049 vss sub sg13_lv_nmos w=1u l=1u m=1
RT1626 vss sub ptap1 A=4e-12 P=8e-6
MM23_110 vout net049 vss sub sg13_lv_nmos w=1u l=1u m=1
RT1627 vss sub ptap1 A=4e-12 P=8e-6
MM23_111 vout net049 vss sub sg13_lv_nmos w=1u l=1u m=1
RT1628 vss sub ptap1 A=4e-12 P=8e-6
MM23_112 vout net049 vss sub sg13_lv_nmos w=1u l=1u m=1
RT1629 vss sub ptap1 A=4e-12 P=8e-6
MM23_113 vout net049 vss sub sg13_lv_nmos w=1u l=1u m=1
RT1630 vss sub ptap1 A=4e-12 P=8e-6
MM23_114 vout net049 vss sub sg13_lv_nmos w=1u l=1u m=1
RT1631 vss sub ptap1 A=4e-12 P=8e-6
MM23_115 vout net049 vss sub sg13_lv_nmos w=1u l=1u m=1
RT1632 vss sub ptap1 A=4e-12 P=8e-6
MM23_116 vout net049 vss sub sg13_lv_nmos w=1u l=1u m=1
RT1633 vss sub ptap1 A=4e-12 P=8e-6
MM23_117 vout net049 vss sub sg13_lv_nmos w=1u l=1u m=1
RT1634 vss sub ptap1 A=4e-12 P=8e-6
MM23_118 vout net049 vss sub sg13_lv_nmos w=1u l=1u m=1
RT1635 vss sub ptap1 A=4e-12 P=8e-6
MM23_119 vout net049 vss sub sg13_lv_nmos w=1u l=1u m=1
RT1636 vss sub ptap1 A=4e-12 P=8e-6
MM23_120 vout net049 vss sub sg13_lv_nmos w=1u l=1u m=1
RT1637 vss sub ptap1 A=4e-12 P=8e-6
MM23_121 vout net049 vss sub sg13_lv_nmos w=1u l=1u m=1
RT1638 vss sub ptap1 A=4e-12 P=8e-6
MM23_122 vout net049 vss sub sg13_lv_nmos w=1u l=1u m=1
RT1639 vss sub ptap1 A=4e-12 P=8e-6
MM23_123 vout net049 vss sub sg13_lv_nmos w=1u l=1u m=1
RT1640 vss sub ptap1 A=4e-12 P=8e-6
MM23_124 vout net049 vss sub sg13_lv_nmos w=1u l=1u m=1
RT1641 vss sub ptap1 A=4e-12 P=8e-6
MM23_125 vout net049 vss sub sg13_lv_nmos w=1u l=1u m=1
RT1642 vss sub ptap1 A=4e-12 P=8e-6
MM23_126 vout net049 vss sub sg13_lv_nmos w=1u l=1u m=1
RT1643 vss sub ptap1 A=4e-12 P=8e-6
MM23_127 vout net049 vss sub sg13_lv_nmos w=1u l=1u m=1
RT1644 vss sub ptap1 A=4e-12 P=8e-6
MM23_128 vout net049 vss sub sg13_lv_nmos w=1u l=1u m=1
RT1645 vss sub ptap1 A=4e-12 P=8e-6
MM23_129 vout net049 vss sub sg13_lv_nmos w=1u l=1u m=1
RT1646 vss sub ptap1 A=4e-12 P=8e-6
MM23_130 vout net049 vss sub sg13_lv_nmos w=1u l=1u m=1
RT1647 vss sub ptap1 A=4e-12 P=8e-6
MM23_131 vout net049 vss sub sg13_lv_nmos w=1u l=1u m=1
RT1648 vss sub ptap1 A=4e-12 P=8e-6
MM23_132 vout net049 vss sub sg13_lv_nmos w=1u l=1u m=1
RT1649 vss sub ptap1 A=4e-12 P=8e-6
MM23_133 vout net049 vss sub sg13_lv_nmos w=1u l=1u m=1
RT1650 vss sub ptap1 A=4e-12 P=8e-6
MM23_134 vout net049 vss sub sg13_lv_nmos w=1u l=1u m=1
RT1651 vss sub ptap1 A=4e-12 P=8e-6
MM23_135 vout net049 vss sub sg13_lv_nmos w=1u l=1u m=1
RT1652 vss sub ptap1 A=4e-12 P=8e-6
MM23_136 vout net049 vss sub sg13_lv_nmos w=1u l=1u m=1
RT1653 vss sub ptap1 A=4e-12 P=8e-6
MM23_137 vout net049 vss sub sg13_lv_nmos w=1u l=1u m=1
RT1654 vss sub ptap1 A=4e-12 P=8e-6
MM23_138 vout net049 vss sub sg13_lv_nmos w=1u l=1u m=1
RT1655 vss sub ptap1 A=4e-12 P=8e-6
MM23_139 vout net049 vss sub sg13_lv_nmos w=1u l=1u m=1
RT1656 vss sub ptap1 A=4e-12 P=8e-6
MM23_140 vout net049 vss sub sg13_lv_nmos w=1u l=1u m=1
RT1657 vss sub ptap1 A=4e-12 P=8e-6
MM23_141 vout net049 vss sub sg13_lv_nmos w=1u l=1u m=1
RT1658 vss sub ptap1 A=4e-12 P=8e-6
MM23_142 vout net049 vss sub sg13_lv_nmos w=1u l=1u m=1
RT1659 vss sub ptap1 A=4e-12 P=8e-6
MM23_143 vout net049 vss sub sg13_lv_nmos w=1u l=1u m=1
RT1660 vss sub ptap1 A=4e-12 P=8e-6
MM23_144 vout net049 vss sub sg13_lv_nmos w=1u l=1u m=1
RT1661 vss sub ptap1 A=4e-12 P=8e-6
MM23_145 vout net049 vss sub sg13_lv_nmos w=1u l=1u m=1
RT1662 vss sub ptap1 A=4e-12 P=8e-6
MM23_146 vout net049 vss sub sg13_lv_nmos w=1u l=1u m=1
RT1663 vss sub ptap1 A=4e-12 P=8e-6
MM23_147 vout net049 vss sub sg13_lv_nmos w=1u l=1u m=1
RT1664 vss sub ptap1 A=4e-12 P=8e-6
MM23_148 vout net049 vss sub sg13_lv_nmos w=1u l=1u m=1
RT1665 vss sub ptap1 A=4e-12 P=8e-6
MM23_149 vout net049 vss sub sg13_lv_nmos w=1u l=1u m=1
RT1666 vss sub ptap1 A=4e-12 P=8e-6
MM23_150 vout net049 vss sub sg13_lv_nmos w=1u l=1u m=1
RT1667 vss sub ptap1 A=4e-12 P=8e-6
MM23_151 vout net049 vss sub sg13_lv_nmos w=1u l=1u m=1
RT1668 vss sub ptap1 A=4e-12 P=8e-6
MM23_152 vout net049 vss sub sg13_lv_nmos w=1u l=1u m=1
RT1669 vss sub ptap1 A=4e-12 P=8e-6
MM23_153 vout net049 vss sub sg13_lv_nmos w=1u l=1u m=1
RT1670 vss sub ptap1 A=4e-12 P=8e-6
MM23_154 vout net049 vss sub sg13_lv_nmos w=1u l=1u m=1
RT1671 vss sub ptap1 A=4e-12 P=8e-6
MM23_155 vout net049 vss sub sg13_lv_nmos w=1u l=1u m=1
RT1672 vss sub ptap1 A=4e-12 P=8e-6
MM23_156 vout net049 vss sub sg13_lv_nmos w=1u l=1u m=1
RT1673 vss sub ptap1 A=4e-12 P=8e-6
MM23_157 vout net049 vss sub sg13_lv_nmos w=1u l=1u m=1
RT1674 vss sub ptap1 A=4e-12 P=8e-6
MM23_158 vout net049 vss sub sg13_lv_nmos w=1u l=1u m=1
RT1675 vss sub ptap1 A=4e-12 P=8e-6
MM23_159 vout net049 vss sub sg13_lv_nmos w=1u l=1u m=1
RT1676 vss sub ptap1 A=4e-12 P=8e-6
MM23_160 vout net049 vss sub sg13_lv_nmos w=1u l=1u m=1
RT1677 vss sub ptap1 A=4e-12 P=8e-6
MM23_161 vout net049 vss sub sg13_lv_nmos w=1u l=1u m=1
RT1678 vss sub ptap1 A=4e-12 P=8e-6
MM23_162 vout net049 vss sub sg13_lv_nmos w=1u l=1u m=1
RT1679 vss sub ptap1 A=4e-12 P=8e-6
MM23_163 vout net049 vss sub sg13_lv_nmos w=1u l=1u m=1
RT1680 vss sub ptap1 A=4e-12 P=8e-6
MM23_164 vout net049 vss sub sg13_lv_nmos w=1u l=1u m=1
RT1681 vss sub ptap1 A=4e-12 P=8e-6
MM23_165 vout net049 vss sub sg13_lv_nmos w=1u l=1u m=1
RT1682 vss sub ptap1 A=4e-12 P=8e-6
MM23_166 vout net049 vss sub sg13_lv_nmos w=1u l=1u m=1
RT1683 vss sub ptap1 A=4e-12 P=8e-6
MM23_167 vout net049 vss sub sg13_lv_nmos w=1u l=1u m=1
RT1684 vss sub ptap1 A=4e-12 P=8e-6
MM23_168 vout net049 vss sub sg13_lv_nmos w=1u l=1u m=1
RT1685 vss sub ptap1 A=4e-12 P=8e-6
MM23_169 vout net049 vss sub sg13_lv_nmos w=1u l=1u m=1
RT1686 vss sub ptap1 A=4e-12 P=8e-6
MM23_170 vout net049 vss sub sg13_lv_nmos w=1u l=1u m=1
RT1687 vss sub ptap1 A=4e-12 P=8e-6
MM23_171 vout net049 vss sub sg13_lv_nmos w=1u l=1u m=1
RT1688 vss sub ptap1 A=4e-12 P=8e-6
MM23_172 vout net049 vss sub sg13_lv_nmos w=1u l=1u m=1
RT1689 vss sub ptap1 A=4e-12 P=8e-6
MM23_173 vout net049 vss sub sg13_lv_nmos w=1u l=1u m=1
RT1690 vss sub ptap1 A=4e-12 P=8e-6
MM23_174 vout net049 vss sub sg13_lv_nmos w=1u l=1u m=1
RT1691 vss sub ptap1 A=4e-12 P=8e-6
MM23_175 vout net049 vss sub sg13_lv_nmos w=1u l=1u m=1
RT1692 vss sub ptap1 A=4e-12 P=8e-6
MM23_176 vout net049 vss sub sg13_lv_nmos w=1u l=1u m=1
RT1693 vss sub ptap1 A=4e-12 P=8e-6
MM23_177 vout net049 vss sub sg13_lv_nmos w=1u l=1u m=1
RT1694 vss sub ptap1 A=4e-12 P=8e-6
MM23_178 vout net049 vss sub sg13_lv_nmos w=1u l=1u m=1
RT1695 vss sub ptap1 A=4e-12 P=8e-6
MM23_179 vout net049 vss sub sg13_lv_nmos w=1u l=1u m=1
RT1696 vss sub ptap1 A=4e-12 P=8e-6
MM23_180 vout net049 vss sub sg13_lv_nmos w=1u l=1u m=1
RT1697 vss sub ptap1 A=4e-12 P=8e-6
MM23_181 vout net049 vss sub sg13_lv_nmos w=1u l=1u m=1
RT1698 vss sub ptap1 A=4e-12 P=8e-6
MM23_182 vout net049 vss sub sg13_lv_nmos w=1u l=1u m=1
RT1699 vss sub ptap1 A=4e-12 P=8e-6
MM23_183 vout net049 vss sub sg13_lv_nmos w=1u l=1u m=1
RT1700 vss sub ptap1 A=4e-12 P=8e-6
MM23_184 vout net049 vss sub sg13_lv_nmos w=1u l=1u m=1
RT1701 vss sub ptap1 A=4e-12 P=8e-6
MM23_185 vout net049 vss sub sg13_lv_nmos w=1u l=1u m=1
RT1702 vss sub ptap1 A=4e-12 P=8e-6
MM23_186 vout net049 vss sub sg13_lv_nmos w=1u l=1u m=1
RT1703 vss sub ptap1 A=4e-12 P=8e-6
MM23_187 vout net049 vss sub sg13_lv_nmos w=1u l=1u m=1
RT1704 vss sub ptap1 A=4e-12 P=8e-6
MM23_188 vout net049 vss sub sg13_lv_nmos w=1u l=1u m=1
RT1705 vss sub ptap1 A=4e-12 P=8e-6
MM23_189 vout net049 vss sub sg13_lv_nmos w=1u l=1u m=1
RT1706 vss sub ptap1 A=4e-12 P=8e-6
MM23_190 vout net049 vss sub sg13_lv_nmos w=1u l=1u m=1
RT1707 vss sub ptap1 A=4e-12 P=8e-6
MM23_191 vout net049 vss sub sg13_lv_nmos w=1u l=1u m=1
RT1708 vss sub ptap1 A=4e-12 P=8e-6
MM23_192 vout net049 vss sub sg13_lv_nmos w=1u l=1u m=1
RT1709 vss sub ptap1 A=4e-12 P=8e-6
MM23_193 vout net049 vss sub sg13_lv_nmos w=1u l=1u m=1
RT1710 vss sub ptap1 A=4e-12 P=8e-6
MM23_194 vout net049 vss sub sg13_lv_nmos w=1u l=1u m=1
RT1711 vss sub ptap1 A=4e-12 P=8e-6
MM23_195 vout net049 vss sub sg13_lv_nmos w=1u l=1u m=1
RT1712 vss sub ptap1 A=4e-12 P=8e-6
MM23_196 vout net049 vss sub sg13_lv_nmos w=1u l=1u m=1
RT1713 vss sub ptap1 A=4e-12 P=8e-6
MM23_197 vout net049 vss sub sg13_lv_nmos w=1u l=1u m=1
RT1714 vss sub ptap1 A=4e-12 P=8e-6
MM23_198 vout net049 vss sub sg13_lv_nmos w=1u l=1u m=1
RT1715 vss sub ptap1 A=4e-12 P=8e-6
MM23_199 vout net049 vss sub sg13_lv_nmos w=1u l=1u m=1
RT1716 vss sub ptap1 A=4e-12 P=8e-6
MM23_200 vout net049 vss sub sg13_lv_nmos w=1u l=1u m=1
RT1717 vss sub ptap1 A=4e-12 P=8e-6
MM23_201 vout net049 vss sub sg13_lv_nmos w=1u l=1u m=1
RT1718 vss sub ptap1 A=4e-12 P=8e-6
MM23_202 vout net049 vss sub sg13_lv_nmos w=1u l=1u m=1
RT1719 vdd well_1719 ntap1 A=4e-12 P=8e-6
MM3_0 vb3 net1 vdd well_1719 sg13_lv_pmos w=1u l=1u m=1
RT1720 vdd well_1720 ntap1 A=4e-12 P=8e-6
MM3_1 vb3 net1 vdd well_1720 sg13_lv_pmos w=1u l=1u m=1
RT1721 vdd well_1721 ntap1 A=4e-12 P=8e-6
MM3_2 vb3 net1 vdd well_1721 sg13_lv_pmos w=1u l=1u m=1
RT1722 vdd well_1722 ntap1 A=4e-12 P=8e-6
MM3_3 vb3 net1 vdd well_1722 sg13_lv_pmos w=1u l=1u m=1
RT1723 vdd well_1723 ntap1 A=4e-12 P=8e-6
MM3_4 vb3 net1 vdd well_1723 sg13_lv_pmos w=1u l=1u m=1
RT1724 vdd well_1724 ntap1 A=4e-12 P=8e-6
MM3_5 vb3 net1 vdd well_1724 sg13_lv_pmos w=1u l=1u m=1
RT1725 vdd well_1725 ntap1 A=4e-12 P=8e-6
MM3_6 vb3 net1 vdd well_1725 sg13_lv_pmos w=1u l=1u m=1
RT1726 vdd well_1726 ntap1 A=4e-12 P=8e-6
MM3_7 vb3 net1 vdd well_1726 sg13_lv_pmos w=1u l=1u m=1
RT1727 vdd well_1727 ntap1 A=4e-12 P=8e-6
MM3_8 vb3 net1 vdd well_1727 sg13_lv_pmos w=1u l=1u m=1
RT1728 vdd well_1728 ntap1 A=4e-12 P=8e-6
MM3_9 vb3 net1 vdd well_1728 sg13_lv_pmos w=1u l=1u m=1
RT1729 vdd well_1729 ntap1 A=4e-12 P=8e-6
MM3_10 vb3 net1 vdd well_1729 sg13_lv_pmos w=1u l=1u m=1
RT1730 vdd well_1730 ntap1 A=4e-12 P=8e-6
MM3_11 vb3 net1 vdd well_1730 sg13_lv_pmos w=1u l=1u m=1
RT1731 vdd well_1731 ntap1 A=4e-12 P=8e-6
MM3_12 vb3 net1 vdd well_1731 sg13_lv_pmos w=1u l=1u m=1
RT1732 vdd well_1732 ntap1 A=4e-12 P=8e-6
MM3_13 vb3 net1 vdd well_1732 sg13_lv_pmos w=1u l=1u m=1
RT1733 vdd well_1733 ntap1 A=4e-12 P=8e-6
MM3_14 vb3 net1 vdd well_1733 sg13_lv_pmos w=1u l=1u m=1
RT1734 vdd well_1734 ntap1 A=4e-12 P=8e-6
MM3_15 vb3 net1 vdd well_1734 sg13_lv_pmos w=1u l=1u m=1
RT1735 vdd well_1735 ntap1 A=4e-12 P=8e-6
MM3_16 vb3 net1 vdd well_1735 sg13_lv_pmos w=1u l=1u m=1
RT1736 vdd well_1736 ntap1 A=4e-12 P=8e-6
MM3_17 vb3 net1 vdd well_1736 sg13_lv_pmos w=1u l=1u m=1
RT1737 vdd well_1737 ntap1 A=4e-12 P=8e-6
MM3_18 vb3 net1 vdd well_1737 sg13_lv_pmos w=1u l=1u m=1
RT1738 vdd well_1738 ntap1 A=4e-12 P=8e-6
MM3_19 vb3 net1 vdd well_1738 sg13_lv_pmos w=1u l=1u m=1
RT1739 vdd well_1739 ntap1 A=4e-12 P=8e-6
MM3_20 vb3 net1 vdd well_1739 sg13_lv_pmos w=1u l=1u m=1
RT1740 vdd well_1740 ntap1 A=4e-12 P=8e-6
MM3_21 vb3 net1 vdd well_1740 sg13_lv_pmos w=1u l=1u m=1
RT1741 vdd well_1741 ntap1 A=4e-12 P=8e-6
MM3_22 vb3 net1 vdd well_1741 sg13_lv_pmos w=1u l=1u m=1
RT1742 vdd well_1742 ntap1 A=4e-12 P=8e-6
MM3_23 vb3 net1 vdd well_1742 sg13_lv_pmos w=1u l=1u m=1
RT1743 vdd well_1743 ntap1 A=4e-12 P=8e-6
MM3_24 vb3 net1 vdd well_1743 sg13_lv_pmos w=1u l=1u m=1
RT1744 vdd well_1744 ntap1 A=4e-12 P=8e-6
MM3_25 vb3 net1 vdd well_1744 sg13_lv_pmos w=1u l=1u m=1
RT1745 vdd well_1745 ntap1 A=4e-12 P=8e-6
MM3_26 vb3 net1 vdd well_1745 sg13_lv_pmos w=1u l=1u m=1
RT1746 vdd well_1746 ntap1 A=4e-12 P=8e-6
MM3_27 vb3 net1 vdd well_1746 sg13_lv_pmos w=1u l=1u m=1
RT1747 vdd well_1747 ntap1 A=4e-12 P=8e-6
MM3_28 vb3 net1 vdd well_1747 sg13_lv_pmos w=1u l=1u m=1
RT1748 vdd well_1748 ntap1 A=4e-12 P=8e-6
MM3_29 vb3 net1 vdd well_1748 sg13_lv_pmos w=1u l=1u m=1
RT1749 vdd well_1749 ntap1 A=4e-12 P=8e-6
MM3_30 vb3 net1 vdd well_1749 sg13_lv_pmos w=1u l=1u m=1
RT1750 vdd well_1750 ntap1 A=4e-12 P=8e-6
MM3_31 vb3 net1 vdd well_1750 sg13_lv_pmos w=1u l=1u m=1
RT1751 vdd well_1751 ntap1 A=4e-12 P=8e-6
MM3_32 vb3 net1 vdd well_1751 sg13_lv_pmos w=1u l=1u m=1
RT1752 vdd well_1752 ntap1 A=4e-12 P=8e-6
MM3_33 vb3 net1 vdd well_1752 sg13_lv_pmos w=1u l=1u m=1
RT1753 vdd well_1753 ntap1 A=4e-12 P=8e-6
MM3_34 vb3 net1 vdd well_1753 sg13_lv_pmos w=1u l=1u m=1
RT1754 vdd well_1754 ntap1 A=4e-12 P=8e-6
MM3_35 vb3 net1 vdd well_1754 sg13_lv_pmos w=1u l=1u m=1
RT1755 vdd well_1755 ntap1 A=4e-12 P=8e-6
MM3_36 vb3 net1 vdd well_1755 sg13_lv_pmos w=1u l=1u m=1
RT1756 vdd well_1756 ntap1 A=4e-12 P=8e-6
MM3_37 vb3 net1 vdd well_1756 sg13_lv_pmos w=1u l=1u m=1
RT1757 vdd well_1757 ntap1 A=4e-12 P=8e-6
MM3_38 vb3 net1 vdd well_1757 sg13_lv_pmos w=1u l=1u m=1
RT1758 vdd well_1758 ntap1 A=4e-12 P=8e-6
MM3_39 vb3 net1 vdd well_1758 sg13_lv_pmos w=1u l=1u m=1
RT1759 vdd well_1759 ntap1 A=4e-12 P=8e-6
MM3_40 vb3 net1 vdd well_1759 sg13_lv_pmos w=1u l=1u m=1
RT1760 vdd well_1760 ntap1 A=4e-12 P=8e-6
MM3_41 vb3 net1 vdd well_1760 sg13_lv_pmos w=1u l=1u m=1
RT1761 vdd well_1761 ntap1 A=4e-12 P=8e-6
MM3_42 vb3 net1 vdd well_1761 sg13_lv_pmos w=1u l=1u m=1
RT1762 vdd well_1762 ntap1 A=4e-12 P=8e-6
MM3_43 vb3 net1 vdd well_1762 sg13_lv_pmos w=1u l=1u m=1
RT1763 vdd well_1763 ntap1 A=4e-12 P=8e-6
MM3_44 vb3 net1 vdd well_1763 sg13_lv_pmos w=1u l=1u m=1
RT1764 vdd well_1764 ntap1 A=4e-12 P=8e-6
MM3_45 vb3 net1 vdd well_1764 sg13_lv_pmos w=1u l=1u m=1
RT1765 vdd well_1765 ntap1 A=4e-12 P=8e-6
MM3_46 vb3 net1 vdd well_1765 sg13_lv_pmos w=1u l=1u m=1
RT1766 vdd well_1766 ntap1 A=4e-12 P=8e-6
MM3_47 vb3 net1 vdd well_1766 sg13_lv_pmos w=1u l=1u m=1
RT1767 vdd well_1767 ntap1 A=4e-12 P=8e-6
MM3_48 vb3 net1 vdd well_1767 sg13_lv_pmos w=1u l=1u m=1
RT1768 vdd well_1768 ntap1 A=4e-12 P=8e-6
MM3_49 vb3 net1 vdd well_1768 sg13_lv_pmos w=1u l=1u m=1
RT1769 vdd well_1769 ntap1 A=4e-12 P=8e-6
MM3_50 vb3 net1 vdd well_1769 sg13_lv_pmos w=1u l=1u m=1
RT1770 vdd well_1770 ntap1 A=4e-12 P=8e-6
MM3_51 vb3 net1 vdd well_1770 sg13_lv_pmos w=1u l=1u m=1
RT1771 vdd well_1771 ntap1 A=4e-12 P=8e-6
MM3_52 vb3 net1 vdd well_1771 sg13_lv_pmos w=1u l=1u m=1
RT1772 vdd well_1772 ntap1 A=4e-12 P=8e-6
MM3_53 vb3 net1 vdd well_1772 sg13_lv_pmos w=1u l=1u m=1
RT1773 vdd well_1773 ntap1 A=4e-12 P=8e-6
MM3_54 vb3 net1 vdd well_1773 sg13_lv_pmos w=1u l=1u m=1
RT1774 vdd well_1774 ntap1 A=4e-12 P=8e-6
MM3_55 vb3 net1 vdd well_1774 sg13_lv_pmos w=1u l=1u m=1
RT1775 vdd well_1775 ntap1 A=4e-12 P=8e-6
MM3_56 vb3 net1 vdd well_1775 sg13_lv_pmos w=1u l=1u m=1
RT1776 vdd well_1776 ntap1 A=4e-12 P=8e-6
MM3_57 vb3 net1 vdd well_1776 sg13_lv_pmos w=1u l=1u m=1
RT1777 vdd well_1777 ntap1 A=4e-12 P=8e-6
MM3_58 vb3 net1 vdd well_1777 sg13_lv_pmos w=1u l=1u m=1
RT1778 vdd well_1778 ntap1 A=4e-12 P=8e-6
MM3_59 vb3 net1 vdd well_1778 sg13_lv_pmos w=1u l=1u m=1
RT1779 vdd well_1779 ntap1 A=4e-12 P=8e-6
MM3_60 vb3 net1 vdd well_1779 sg13_lv_pmos w=1u l=1u m=1
RT1780 vdd well_1780 ntap1 A=4e-12 P=8e-6
MM3_61 vb3 net1 vdd well_1780 sg13_lv_pmos w=1u l=1u m=1
RT1781 vdd well_1781 ntap1 A=4e-12 P=8e-6
MM3_62 vb3 net1 vdd well_1781 sg13_lv_pmos w=1u l=1u m=1
RT1782 vdd well_1782 ntap1 A=4e-12 P=8e-6
MM3_63 vb3 net1 vdd well_1782 sg13_lv_pmos w=1u l=1u m=1
RT1783 vdd well_1783 ntap1 A=4e-12 P=8e-6
MM3_64 vb3 net1 vdd well_1783 sg13_lv_pmos w=1u l=1u m=1
RT1784 vdd well_1784 ntap1 A=4e-12 P=8e-6
MM3_65 vb3 net1 vdd well_1784 sg13_lv_pmos w=1u l=1u m=1
RT1785 vdd well_1785 ntap1 A=4e-12 P=8e-6
MM3_66 vb3 net1 vdd well_1785 sg13_lv_pmos w=1u l=1u m=1
RT1786 vdd well_1786 ntap1 A=4e-12 P=8e-6
MM3_67 vb3 net1 vdd well_1786 sg13_lv_pmos w=1u l=1u m=1
RT1787 vdd well_1787 ntap1 A=4e-12 P=8e-6
MM3_68 vb3 net1 vdd well_1787 sg13_lv_pmos w=1u l=1u m=1
RT1788 vdd well_1788 ntap1 A=4e-12 P=8e-6
MM3_69 vb3 net1 vdd well_1788 sg13_lv_pmos w=1u l=1u m=1
RT1789 vdd well_1789 ntap1 A=4e-12 P=8e-6
MM3_70 vb3 net1 vdd well_1789 sg13_lv_pmos w=1u l=1u m=1
RT1790 vdd well_1790 ntap1 A=4e-12 P=8e-6
MM4_0 net31 net1 vdd well_1790 sg13_lv_pmos w=1u l=1u m=1
RT1791 vdd well_1791 ntap1 A=4e-12 P=8e-6
MM4_1 net31 net1 vdd well_1791 sg13_lv_pmos w=1u l=1u m=1
RT1792 vdd well_1792 ntap1 A=4e-12 P=8e-6
MM4_2 net31 net1 vdd well_1792 sg13_lv_pmos w=1u l=1u m=1
RT1793 vdd well_1793 ntap1 A=4e-12 P=8e-6
MM4_3 net31 net1 vdd well_1793 sg13_lv_pmos w=1u l=1u m=1
RT1794 vdd well_1794 ntap1 A=4e-12 P=8e-6
MM4_4 net31 net1 vdd well_1794 sg13_lv_pmos w=1u l=1u m=1
RT1795 vdd well_1795 ntap1 A=4e-12 P=8e-6
MM4_5 net31 net1 vdd well_1795 sg13_lv_pmos w=1u l=1u m=1
RT1796 vdd well_1796 ntap1 A=4e-12 P=8e-6
MM4_6 net31 net1 vdd well_1796 sg13_lv_pmos w=1u l=1u m=1
RT1797 vdd well_1797 ntap1 A=4e-12 P=8e-6
MM4_7 net31 net1 vdd well_1797 sg13_lv_pmos w=1u l=1u m=1
RT1798 vdd well_1798 ntap1 A=4e-12 P=8e-6
MM4_8 net31 net1 vdd well_1798 sg13_lv_pmos w=1u l=1u m=1
RT1799 vdd well_1799 ntap1 A=4e-12 P=8e-6
MM4_9 net31 net1 vdd well_1799 sg13_lv_pmos w=1u l=1u m=1
RT1800 vdd well_1800 ntap1 A=4e-12 P=8e-6
MM4_10 net31 net1 vdd well_1800 sg13_lv_pmos w=1u l=1u m=1
RT1801 vdd well_1801 ntap1 A=4e-12 P=8e-6
MM4_11 net31 net1 vdd well_1801 sg13_lv_pmos w=1u l=1u m=1
RT1802 vdd well_1802 ntap1 A=4e-12 P=8e-6
MM4_12 net31 net1 vdd well_1802 sg13_lv_pmos w=1u l=1u m=1
RT1803 vdd well_1803 ntap1 A=4e-12 P=8e-6
MM4_13 net31 net1 vdd well_1803 sg13_lv_pmos w=1u l=1u m=1
RT1804 vdd well_1804 ntap1 A=4e-12 P=8e-6
MM4_14 net31 net1 vdd well_1804 sg13_lv_pmos w=1u l=1u m=1
RT1805 vdd well_1805 ntap1 A=4e-12 P=8e-6
MM4_15 net31 net1 vdd well_1805 sg13_lv_pmos w=1u l=1u m=1
RT1806 vdd well_1806 ntap1 A=4e-12 P=8e-6
MM4_16 net31 net1 vdd well_1806 sg13_lv_pmos w=1u l=1u m=1
RT1807 vdd well_1807 ntap1 A=4e-12 P=8e-6
MM4_17 net31 net1 vdd well_1807 sg13_lv_pmos w=1u l=1u m=1
RT1808 vdd well_1808 ntap1 A=4e-12 P=8e-6
MM4_18 net31 net1 vdd well_1808 sg13_lv_pmos w=1u l=1u m=1
RT1809 vdd well_1809 ntap1 A=4e-12 P=8e-6
MM4_19 net31 net1 vdd well_1809 sg13_lv_pmos w=1u l=1u m=1
RT1810 vdd well_1810 ntap1 A=4e-12 P=8e-6
MM4_20 net31 net1 vdd well_1810 sg13_lv_pmos w=1u l=1u m=1
RT1811 vdd well_1811 ntap1 A=4e-12 P=8e-6
MM4_21 net31 net1 vdd well_1811 sg13_lv_pmos w=1u l=1u m=1
RT1812 vdd well_1812 ntap1 A=4e-12 P=8e-6
MM4_22 net31 net1 vdd well_1812 sg13_lv_pmos w=1u l=1u m=1
RT1813 vdd well_1813 ntap1 A=4e-12 P=8e-6
MM4_23 net31 net1 vdd well_1813 sg13_lv_pmos w=1u l=1u m=1
RT1814 vdd well_1814 ntap1 A=4e-12 P=8e-6
MM4_24 net31 net1 vdd well_1814 sg13_lv_pmos w=1u l=1u m=1
RT1815 vdd well_1815 ntap1 A=4e-12 P=8e-6
MM4_25 net31 net1 vdd well_1815 sg13_lv_pmos w=1u l=1u m=1
RT1816 vdd well_1816 ntap1 A=4e-12 P=8e-6
MM4_26 net31 net1 vdd well_1816 sg13_lv_pmos w=1u l=1u m=1
RT1817 vdd well_1817 ntap1 A=4e-12 P=8e-6
MM4_27 net31 net1 vdd well_1817 sg13_lv_pmos w=1u l=1u m=1
RT1818 vdd well_1818 ntap1 A=4e-12 P=8e-6
MM4_28 net31 net1 vdd well_1818 sg13_lv_pmos w=1u l=1u m=1
RT1819 vdd well_1819 ntap1 A=4e-12 P=8e-6
MM4_29 net31 net1 vdd well_1819 sg13_lv_pmos w=1u l=1u m=1
RT1820 vdd well_1820 ntap1 A=4e-12 P=8e-6
MM4_30 net31 net1 vdd well_1820 sg13_lv_pmos w=1u l=1u m=1
RT1821 vdd well_1821 ntap1 A=4e-12 P=8e-6
MM4_31 net31 net1 vdd well_1821 sg13_lv_pmos w=1u l=1u m=1
RT1822 vdd well_1822 ntap1 A=4e-12 P=8e-6
MM4_32 net31 net1 vdd well_1822 sg13_lv_pmos w=1u l=1u m=1
RT1823 vdd well_1823 ntap1 A=4e-12 P=8e-6
MM4_33 net31 net1 vdd well_1823 sg13_lv_pmos w=1u l=1u m=1
RT1824 vdd well_1824 ntap1 A=4e-12 P=8e-6
MM4_34 net31 net1 vdd well_1824 sg13_lv_pmos w=1u l=1u m=1
RT1825 vdd well_1825 ntap1 A=4e-12 P=8e-6
MM4_35 net31 net1 vdd well_1825 sg13_lv_pmos w=1u l=1u m=1
RT1826 vdd well_1826 ntap1 A=4e-12 P=8e-6
MM4_36 net31 net1 vdd well_1826 sg13_lv_pmos w=1u l=1u m=1
RT1827 vdd well_1827 ntap1 A=4e-12 P=8e-6
MM4_37 net31 net1 vdd well_1827 sg13_lv_pmos w=1u l=1u m=1
RT1828 vdd well_1828 ntap1 A=4e-12 P=8e-6
MM4_38 net31 net1 vdd well_1828 sg13_lv_pmos w=1u l=1u m=1
RT1829 vdd well_1829 ntap1 A=4e-12 P=8e-6
MM4_39 net31 net1 vdd well_1829 sg13_lv_pmos w=1u l=1u m=1
RT1830 vdd well_1830 ntap1 A=4e-12 P=8e-6
MM4_40 net31 net1 vdd well_1830 sg13_lv_pmos w=1u l=1u m=1
RT1831 vdd well_1831 ntap1 A=4e-12 P=8e-6
MM4_41 net31 net1 vdd well_1831 sg13_lv_pmos w=1u l=1u m=1
RT1832 vdd well_1832 ntap1 A=4e-12 P=8e-6
MM4_42 net31 net1 vdd well_1832 sg13_lv_pmos w=1u l=1u m=1
RT1833 vdd well_1833 ntap1 A=4e-12 P=8e-6
MM4_43 net31 net1 vdd well_1833 sg13_lv_pmos w=1u l=1u m=1
RT1834 vdd well_1834 ntap1 A=4e-12 P=8e-6
MM4_44 net31 net1 vdd well_1834 sg13_lv_pmos w=1u l=1u m=1
RT1835 vdd well_1835 ntap1 A=4e-12 P=8e-6
MM4_45 net31 net1 vdd well_1835 sg13_lv_pmos w=1u l=1u m=1
RT1836 vdd well_1836 ntap1 A=4e-12 P=8e-6
MM4_46 net31 net1 vdd well_1836 sg13_lv_pmos w=1u l=1u m=1
RT1837 vdd well_1837 ntap1 A=4e-12 P=8e-6
MM4_47 net31 net1 vdd well_1837 sg13_lv_pmos w=1u l=1u m=1
RT1838 vdd well_1838 ntap1 A=4e-12 P=8e-6
MM4_48 net31 net1 vdd well_1838 sg13_lv_pmos w=1u l=1u m=1
RT1839 vdd well_1839 ntap1 A=4e-12 P=8e-6
MM4_49 net31 net1 vdd well_1839 sg13_lv_pmos w=1u l=1u m=1
RT1840 vdd well_1840 ntap1 A=4e-12 P=8e-6
MM4_50 net31 net1 vdd well_1840 sg13_lv_pmos w=1u l=1u m=1
RT1841 vdd well_1841 ntap1 A=4e-12 P=8e-6
MM4_51 net31 net1 vdd well_1841 sg13_lv_pmos w=1u l=1u m=1
RT1842 vdd well_1842 ntap1 A=4e-12 P=8e-6
MM4_52 net31 net1 vdd well_1842 sg13_lv_pmos w=1u l=1u m=1
RT1843 vdd well_1843 ntap1 A=4e-12 P=8e-6
MM4_53 net31 net1 vdd well_1843 sg13_lv_pmos w=1u l=1u m=1
RT1844 vdd well_1844 ntap1 A=4e-12 P=8e-6
MM4_54 net31 net1 vdd well_1844 sg13_lv_pmos w=1u l=1u m=1
RT1845 vdd well_1845 ntap1 A=4e-12 P=8e-6
MM4_55 net31 net1 vdd well_1845 sg13_lv_pmos w=1u l=1u m=1
RT1846 vdd well_1846 ntap1 A=4e-12 P=8e-6
MM4_56 net31 net1 vdd well_1846 sg13_lv_pmos w=1u l=1u m=1
RT1847 vdd well_1847 ntap1 A=4e-12 P=8e-6
MM4_57 net31 net1 vdd well_1847 sg13_lv_pmos w=1u l=1u m=1
RT1848 vdd well_1848 ntap1 A=4e-12 P=8e-6
MM4_58 net31 net1 vdd well_1848 sg13_lv_pmos w=1u l=1u m=1
RT1849 vdd well_1849 ntap1 A=4e-12 P=8e-6
MM4_59 net31 net1 vdd well_1849 sg13_lv_pmos w=1u l=1u m=1
RT1850 vdd well_1850 ntap1 A=4e-12 P=8e-6
MM4_60 net31 net1 vdd well_1850 sg13_lv_pmos w=1u l=1u m=1
RT1851 vdd well_1851 ntap1 A=4e-12 P=8e-6
MM4_61 net31 net1 vdd well_1851 sg13_lv_pmos w=1u l=1u m=1
RT1852 vdd well_1852 ntap1 A=4e-12 P=8e-6
MM4_62 net31 net1 vdd well_1852 sg13_lv_pmos w=1u l=1u m=1
RT1853 vdd well_1853 ntap1 A=4e-12 P=8e-6
MM4_63 net31 net1 vdd well_1853 sg13_lv_pmos w=1u l=1u m=1
RT1854 vdd well_1854 ntap1 A=4e-12 P=8e-6
MM4_64 net31 net1 vdd well_1854 sg13_lv_pmos w=1u l=1u m=1
RT1855 vdd well_1855 ntap1 A=4e-12 P=8e-6
MM4_65 net31 net1 vdd well_1855 sg13_lv_pmos w=1u l=1u m=1
RT1856 vdd well_1856 ntap1 A=4e-12 P=8e-6
MM4_66 net31 net1 vdd well_1856 sg13_lv_pmos w=1u l=1u m=1
RT1857 vdd well_1857 ntap1 A=4e-12 P=8e-6
MM4_67 net31 net1 vdd well_1857 sg13_lv_pmos w=1u l=1u m=1
RT1858 vdd well_1858 ntap1 A=4e-12 P=8e-6
MM4_68 net31 net1 vdd well_1858 sg13_lv_pmos w=1u l=1u m=1
RT1859 vdd well_1859 ntap1 A=4e-12 P=8e-6
MM4_69 net31 net1 vdd well_1859 sg13_lv_pmos w=1u l=1u m=1
RT1860 vdd well_1860 ntap1 A=4e-12 P=8e-6
MM4_70 net31 net1 vdd well_1860 sg13_lv_pmos w=1u l=1u m=1
RT1861 vdd well_1861 ntap1 A=4e-12 P=8e-6
MM4_71 net31 net1 vdd well_1861 sg13_lv_pmos w=1u l=1u m=1
RT1862 vdd well_1862 ntap1 A=4e-12 P=8e-6
MM4_72 net31 net1 vdd well_1862 sg13_lv_pmos w=1u l=1u m=1
RT1863 vdd well_1863 ntap1 A=4e-12 P=8e-6
MM4_73 net31 net1 vdd well_1863 sg13_lv_pmos w=1u l=1u m=1
RT1864 vdd well_1864 ntap1 A=4e-12 P=8e-6
MM4_74 net31 net1 vdd well_1864 sg13_lv_pmos w=1u l=1u m=1
RT1865 vdd well_1865 ntap1 A=4e-12 P=8e-6
MM4_75 net31 net1 vdd well_1865 sg13_lv_pmos w=1u l=1u m=1
RT1866 vdd well_1866 ntap1 A=4e-12 P=8e-6
MM4_76 net31 net1 vdd well_1866 sg13_lv_pmos w=1u l=1u m=1
RT1867 vdd well_1867 ntap1 A=4e-12 P=8e-6
MM4_77 net31 net1 vdd well_1867 sg13_lv_pmos w=1u l=1u m=1
RT1868 vdd well_1868 ntap1 A=4e-12 P=8e-6
MM4_78 net31 net1 vdd well_1868 sg13_lv_pmos w=1u l=1u m=1
RT1869 vdd well_1869 ntap1 A=4e-12 P=8e-6
MM4_79 net31 net1 vdd well_1869 sg13_lv_pmos w=1u l=1u m=1
RT1870 vdd well_1870 ntap1 A=4e-12 P=8e-6
MM4_80 net31 net1 vdd well_1870 sg13_lv_pmos w=1u l=1u m=1
RT1871 vdd well_1871 ntap1 A=4e-12 P=8e-6
MM4_81 net31 net1 vdd well_1871 sg13_lv_pmos w=1u l=1u m=1
RT1872 vdd well_1872 ntap1 A=4e-12 P=8e-6
MM4_82 net31 net1 vdd well_1872 sg13_lv_pmos w=1u l=1u m=1
RT1873 vdd well_1873 ntap1 A=4e-12 P=8e-6
MM4_83 net31 net1 vdd well_1873 sg13_lv_pmos w=1u l=1u m=1
RT1874 vdd well_1874 ntap1 A=4e-12 P=8e-6
MM4_84 net31 net1 vdd well_1874 sg13_lv_pmos w=1u l=1u m=1
RT1875 vdd well_1875 ntap1 A=4e-12 P=8e-6
MM4_85 net31 net1 vdd well_1875 sg13_lv_pmos w=1u l=1u m=1
RT1876 vdd well_1876 ntap1 A=4e-12 P=8e-6
MM4_86 net31 net1 vdd well_1876 sg13_lv_pmos w=1u l=1u m=1
RT1877 vdd well_1877 ntap1 A=4e-12 P=8e-6
MM4_87 net31 net1 vdd well_1877 sg13_lv_pmos w=1u l=1u m=1
RT1878 vdd well_1878 ntap1 A=4e-12 P=8e-6
MM4_88 net31 net1 vdd well_1878 sg13_lv_pmos w=1u l=1u m=1
RT1879 vdd well_1879 ntap1 A=4e-12 P=8e-6
MM4_89 net31 net1 vdd well_1879 sg13_lv_pmos w=1u l=1u m=1
RT1880 vdd well_1880 ntap1 A=4e-12 P=8e-6
MM4_90 net31 net1 vdd well_1880 sg13_lv_pmos w=1u l=1u m=1
RT1881 vdd well_1881 ntap1 A=4e-12 P=8e-6
MM4_91 net31 net1 vdd well_1881 sg13_lv_pmos w=1u l=1u m=1
RT1882 vdd well_1882 ntap1 A=4e-12 P=8e-6
MM4_92 net31 net1 vdd well_1882 sg13_lv_pmos w=1u l=1u m=1
RT1883 vdd well_1883 ntap1 A=4e-12 P=8e-6
MM4_93 net31 net1 vdd well_1883 sg13_lv_pmos w=1u l=1u m=1
RT1884 vdd well_1884 ntap1 A=4e-12 P=8e-6
MM4_94 net31 net1 vdd well_1884 sg13_lv_pmos w=1u l=1u m=1
RT1885 vdd well_1885 ntap1 A=4e-12 P=8e-6
MM4_95 net31 net1 vdd well_1885 sg13_lv_pmos w=1u l=1u m=1
RT1886 vdd well_1886 ntap1 A=4e-12 P=8e-6
MM4_96 net31 net1 vdd well_1886 sg13_lv_pmos w=1u l=1u m=1
RT1887 vdd well_1887 ntap1 A=4e-12 P=8e-6
MM4_97 net31 net1 vdd well_1887 sg13_lv_pmos w=1u l=1u m=1
RT1888 vdd well_1888 ntap1 A=4e-12 P=8e-6
MM4_98 net31 net1 vdd well_1888 sg13_lv_pmos w=1u l=1u m=1
RT1889 vdd well_1889 ntap1 A=4e-12 P=8e-6
MM4_99 net31 net1 vdd well_1889 sg13_lv_pmos w=1u l=1u m=1
RT1890 vdd well_1890 ntap1 A=4e-12 P=8e-6
MM4_100 net31 net1 vdd well_1890 sg13_lv_pmos w=1u l=1u m=1
RT1891 vdd well_1891 ntap1 A=4e-12 P=8e-6
MM4_101 net31 net1 vdd well_1891 sg13_lv_pmos w=1u l=1u m=1
RT1892 vdd well_1892 ntap1 A=4e-12 P=8e-6
MM4_102 net31 net1 vdd well_1892 sg13_lv_pmos w=1u l=1u m=1
RT1893 vdd well_1893 ntap1 A=4e-12 P=8e-6
MM4_103 net31 net1 vdd well_1893 sg13_lv_pmos w=1u l=1u m=1
RT1894 vdd well_1894 ntap1 A=4e-12 P=8e-6
MM4_104 net31 net1 vdd well_1894 sg13_lv_pmos w=1u l=1u m=1
RT1895 vdd well_1895 ntap1 A=4e-12 P=8e-6
MM4_105 net31 net1 vdd well_1895 sg13_lv_pmos w=1u l=1u m=1
RT1896 vdd well_1896 ntap1 A=4e-12 P=8e-6
MM4_106 net31 net1 vdd well_1896 sg13_lv_pmos w=1u l=1u m=1
RT1897 vdd well_1897 ntap1 A=4e-12 P=8e-6
MM4_107 net31 net1 vdd well_1897 sg13_lv_pmos w=1u l=1u m=1
RT1898 vdd well_1898 ntap1 A=4e-12 P=8e-6
MM4_108 net31 net1 vdd well_1898 sg13_lv_pmos w=1u l=1u m=1
RT1899 vdd well_1899 ntap1 A=4e-12 P=8e-6
MM4_109 net31 net1 vdd well_1899 sg13_lv_pmos w=1u l=1u m=1
RT1900 vdd well_1900 ntap1 A=4e-12 P=8e-6
MM4_110 net31 net1 vdd well_1900 sg13_lv_pmos w=1u l=1u m=1
RT1901 vdd well_1901 ntap1 A=4e-12 P=8e-6
MM4_111 net31 net1 vdd well_1901 sg13_lv_pmos w=1u l=1u m=1
RT1902 vdd well_1902 ntap1 A=4e-12 P=8e-6
MM4_112 net31 net1 vdd well_1902 sg13_lv_pmos w=1u l=1u m=1
RT1903 vdd well_1903 ntap1 A=4e-12 P=8e-6
MM4_113 net31 net1 vdd well_1903 sg13_lv_pmos w=1u l=1u m=1
RT1904 vdd well_1904 ntap1 A=4e-12 P=8e-6
MM4_114 net31 net1 vdd well_1904 sg13_lv_pmos w=1u l=1u m=1
RT1905 vdd well_1905 ntap1 A=4e-12 P=8e-6
MM4_115 net31 net1 vdd well_1905 sg13_lv_pmos w=1u l=1u m=1
RT1906 vdd well_1906 ntap1 A=4e-12 P=8e-6
MM4_116 net31 net1 vdd well_1906 sg13_lv_pmos w=1u l=1u m=1
RT1907 vdd well_1907 ntap1 A=4e-12 P=8e-6
MM4_117 net31 net1 vdd well_1907 sg13_lv_pmos w=1u l=1u m=1
RT1908 vdd well_1908 ntap1 A=4e-12 P=8e-6
MM4_118 net31 net1 vdd well_1908 sg13_lv_pmos w=1u l=1u m=1
RT1909 vdd well_1909 ntap1 A=4e-12 P=8e-6
MM4_119 net31 net1 vdd well_1909 sg13_lv_pmos w=1u l=1u m=1
RT1910 vdd well_1910 ntap1 A=4e-12 P=8e-6
MM4_120 net31 net1 vdd well_1910 sg13_lv_pmos w=1u l=1u m=1
RT1911 vdd well_1911 ntap1 A=4e-12 P=8e-6
MM4_121 net31 net1 vdd well_1911 sg13_lv_pmos w=1u l=1u m=1
RT1912 vdd well_1912 ntap1 A=4e-12 P=8e-6
MM4_122 net31 net1 vdd well_1912 sg13_lv_pmos w=1u l=1u m=1
RT1913 vdd well_1913 ntap1 A=4e-12 P=8e-6
MM4_123 net31 net1 vdd well_1913 sg13_lv_pmos w=1u l=1u m=1
RT1914 vdd well_1914 ntap1 A=4e-12 P=8e-6
MM4_124 net31 net1 vdd well_1914 sg13_lv_pmos w=1u l=1u m=1
RT1915 vdd well_1915 ntap1 A=4e-12 P=8e-6
MM4_125 net31 net1 vdd well_1915 sg13_lv_pmos w=1u l=1u m=1
RT1916 vdd well_1916 ntap1 A=4e-12 P=8e-6
MM4_126 net31 net1 vdd well_1916 sg13_lv_pmos w=1u l=1u m=1
RT1917 vdd well_1917 ntap1 A=4e-12 P=8e-6
MM4_127 net31 net1 vdd well_1917 sg13_lv_pmos w=1u l=1u m=1
RT1918 vdd well_1918 ntap1 A=4e-12 P=8e-6
MM4_128 net31 net1 vdd well_1918 sg13_lv_pmos w=1u l=1u m=1
RT1919 vdd well_1919 ntap1 A=4e-12 P=8e-6
MM4_129 net31 net1 vdd well_1919 sg13_lv_pmos w=1u l=1u m=1
RT1920 vdd well_1920 ntap1 A=4e-12 P=8e-6
MM4_130 net31 net1 vdd well_1920 sg13_lv_pmos w=1u l=1u m=1
RT1921 vdd well_1921 ntap1 A=4e-12 P=8e-6
MM4_131 net31 net1 vdd well_1921 sg13_lv_pmos w=1u l=1u m=1
RT1922 vdd well_1922 ntap1 A=4e-12 P=8e-6
MM4_132 net31 net1 vdd well_1922 sg13_lv_pmos w=1u l=1u m=1
RT1923 vdd well_1923 ntap1 A=4e-12 P=8e-6
MM4_133 net31 net1 vdd well_1923 sg13_lv_pmos w=1u l=1u m=1
RT1924 vdd well_1924 ntap1 A=4e-12 P=8e-6
MM4_134 net31 net1 vdd well_1924 sg13_lv_pmos w=1u l=1u m=1
RT1925 vdd well_1925 ntap1 A=4e-12 P=8e-6
MM4_135 net31 net1 vdd well_1925 sg13_lv_pmos w=1u l=1u m=1
RT1926 vdd well_1926 ntap1 A=4e-12 P=8e-6
MM4_136 net31 net1 vdd well_1926 sg13_lv_pmos w=1u l=1u m=1
RT1927 vdd well_1927 ntap1 A=4e-12 P=8e-6
MM4_137 net31 net1 vdd well_1927 sg13_lv_pmos w=1u l=1u m=1
RT1928 vdd well_1928 ntap1 A=4e-12 P=8e-6
MM4_138 net31 net1 vdd well_1928 sg13_lv_pmos w=1u l=1u m=1
RT1929 vdd well_1929 ntap1 A=4e-12 P=8e-6
MM4_139 net31 net1 vdd well_1929 sg13_lv_pmos w=1u l=1u m=1
RT1930 vdd well_1930 ntap1 A=4e-12 P=8e-6
MM4_140 net31 net1 vdd well_1930 sg13_lv_pmos w=1u l=1u m=1
RT1931 vdd well_1931 ntap1 A=4e-12 P=8e-6
MM4_141 net31 net1 vdd well_1931 sg13_lv_pmos w=1u l=1u m=1
RT1932 vdd well_1932 ntap1 A=4e-12 P=8e-6
MM4_142 net31 net1 vdd well_1932 sg13_lv_pmos w=1u l=1u m=1
RT1933 vdd well_1933 ntap1 A=4e-12 P=8e-6
MM4_143 net31 net1 vdd well_1933 sg13_lv_pmos w=1u l=1u m=1
RT1934 vdd well_1934 ntap1 A=4e-12 P=8e-6
MM4_144 net31 net1 vdd well_1934 sg13_lv_pmos w=1u l=1u m=1
RT1935 vdd well_1935 ntap1 A=4e-12 P=8e-6
MM4_145 net31 net1 vdd well_1935 sg13_lv_pmos w=1u l=1u m=1
RT1936 vdd well_1936 ntap1 A=4e-12 P=8e-6
MM4_146 net31 net1 vdd well_1936 sg13_lv_pmos w=1u l=1u m=1
RT1937 vdd well_1937 ntap1 A=4e-12 P=8e-6
MM4_147 net31 net1 vdd well_1937 sg13_lv_pmos w=1u l=1u m=1
RT1938 vdd well_1938 ntap1 A=4e-12 P=8e-6
MM4_148 net31 net1 vdd well_1938 sg13_lv_pmos w=1u l=1u m=1
RT1939 vdd well_1939 ntap1 A=4e-12 P=8e-6
MM4_149 net31 net1 vdd well_1939 sg13_lv_pmos w=1u l=1u m=1
RT1940 vdd well_1940 ntap1 A=4e-12 P=8e-6
MM4_150 net31 net1 vdd well_1940 sg13_lv_pmos w=1u l=1u m=1
RT1941 vdd well_1941 ntap1 A=4e-12 P=8e-6
MM4_151 net31 net1 vdd well_1941 sg13_lv_pmos w=1u l=1u m=1
RT1942 vdd well_1942 ntap1 A=4e-12 P=8e-6
MM4_152 net31 net1 vdd well_1942 sg13_lv_pmos w=1u l=1u m=1
RT1943 vdd well_1943 ntap1 A=4e-12 P=8e-6
MM4_153 net31 net1 vdd well_1943 sg13_lv_pmos w=1u l=1u m=1
RT1944 vdd well_1944 ntap1 A=4e-12 P=8e-6
MM4_154 net31 net1 vdd well_1944 sg13_lv_pmos w=1u l=1u m=1
RT1945 vdd well_1945 ntap1 A=4e-12 P=8e-6
MM4_155 net31 net1 vdd well_1945 sg13_lv_pmos w=1u l=1u m=1
RT1946 vdd well_1946 ntap1 A=4e-12 P=8e-6
MM4_156 net31 net1 vdd well_1946 sg13_lv_pmos w=1u l=1u m=1
RT1947 vdd well_1947 ntap1 A=4e-12 P=8e-6
MM4_157 net31 net1 vdd well_1947 sg13_lv_pmos w=1u l=1u m=1
RT1948 vdd well_1948 ntap1 A=4e-12 P=8e-6
MM4_158 net31 net1 vdd well_1948 sg13_lv_pmos w=1u l=1u m=1
RT1949 vdd well_1949 ntap1 A=4e-12 P=8e-6
MM4_159 net31 net1 vdd well_1949 sg13_lv_pmos w=1u l=1u m=1
RT1950 vdd well_1950 ntap1 A=4e-12 P=8e-6
MM4_160 net31 net1 vdd well_1950 sg13_lv_pmos w=1u l=1u m=1
RT1951 vdd well_1951 ntap1 A=4e-12 P=8e-6
MM4_161 net31 net1 vdd well_1951 sg13_lv_pmos w=1u l=1u m=1
RT1952 vdd well_1952 ntap1 A=4e-12 P=8e-6
MM4_162 net31 net1 vdd well_1952 sg13_lv_pmos w=1u l=1u m=1
RT1953 vdd well_1953 ntap1 A=4e-12 P=8e-6
MM4_163 net31 net1 vdd well_1953 sg13_lv_pmos w=1u l=1u m=1
RT1954 vdd well_1954 ntap1 A=4e-12 P=8e-6
MM4_164 net31 net1 vdd well_1954 sg13_lv_pmos w=1u l=1u m=1
RT1955 vdd well_1955 ntap1 A=4e-12 P=8e-6
MM4_165 net31 net1 vdd well_1955 sg13_lv_pmos w=1u l=1u m=1
RT1956 vdd well_1956 ntap1 A=4e-12 P=8e-6
MM4_166 net31 net1 vdd well_1956 sg13_lv_pmos w=1u l=1u m=1
RT1957 vdd well_1957 ntap1 A=4e-12 P=8e-6
MM4_167 net31 net1 vdd well_1957 sg13_lv_pmos w=1u l=1u m=1
RT1958 vdd well_1958 ntap1 A=4e-12 P=8e-6
MM4_168 net31 net1 vdd well_1958 sg13_lv_pmos w=1u l=1u m=1
RT1959 vdd well_1959 ntap1 A=4e-12 P=8e-6
MM4_169 net31 net1 vdd well_1959 sg13_lv_pmos w=1u l=1u m=1
RT1960 vdd well_1960 ntap1 A=4e-12 P=8e-6
MM4_170 net31 net1 vdd well_1960 sg13_lv_pmos w=1u l=1u m=1
RT1961 vdd well_1961 ntap1 A=4e-12 P=8e-6
MM4_171 net31 net1 vdd well_1961 sg13_lv_pmos w=1u l=1u m=1
RT1962 vdd well_1962 ntap1 A=4e-12 P=8e-6
MM4_172 net31 net1 vdd well_1962 sg13_lv_pmos w=1u l=1u m=1
RT1963 vdd well_1963 ntap1 A=4e-12 P=8e-6
MM4_173 net31 net1 vdd well_1963 sg13_lv_pmos w=1u l=1u m=1
RT1964 vdd well_1964 ntap1 A=4e-12 P=8e-6
MM4_174 net31 net1 vdd well_1964 sg13_lv_pmos w=1u l=1u m=1
RT1965 vdd well_1965 ntap1 A=4e-12 P=8e-6
MM4_175 net31 net1 vdd well_1965 sg13_lv_pmos w=1u l=1u m=1
RT1966 vdd well_1966 ntap1 A=4e-12 P=8e-6
MM4_176 net31 net1 vdd well_1966 sg13_lv_pmos w=1u l=1u m=1
RT1967 vdd well_1967 ntap1 A=4e-12 P=8e-6
MM4_177 net31 net1 vdd well_1967 sg13_lv_pmos w=1u l=1u m=1
RT1968 vdd well_1968 ntap1 A=4e-12 P=8e-6
MM4_178 net31 net1 vdd well_1968 sg13_lv_pmos w=1u l=1u m=1
RT1969 vdd well_1969 ntap1 A=4e-12 P=8e-6
MM4_179 net31 net1 vdd well_1969 sg13_lv_pmos w=1u l=1u m=1
RT1970 vdd well_1970 ntap1 A=4e-12 P=8e-6
MM4_180 net31 net1 vdd well_1970 sg13_lv_pmos w=1u l=1u m=1
RT1971 vdd well_1971 ntap1 A=4e-12 P=8e-6
MM4_181 net31 net1 vdd well_1971 sg13_lv_pmos w=1u l=1u m=1
RT1972 vdd well_1972 ntap1 A=4e-12 P=8e-6
MM4_182 net31 net1 vdd well_1972 sg13_lv_pmos w=1u l=1u m=1
RT1973 vdd well_1973 ntap1 A=4e-12 P=8e-6
MM4_183 net31 net1 vdd well_1973 sg13_lv_pmos w=1u l=1u m=1
RT1974 vdd well_1974 ntap1 A=4e-12 P=8e-6
MM4_184 net31 net1 vdd well_1974 sg13_lv_pmos w=1u l=1u m=1
RT1975 vdd well_1975 ntap1 A=4e-12 P=8e-6
MM4_185 net31 net1 vdd well_1975 sg13_lv_pmos w=1u l=1u m=1
RT1976 vdd well_1976 ntap1 A=4e-12 P=8e-6
MM4_186 net31 net1 vdd well_1976 sg13_lv_pmos w=1u l=1u m=1
RT1977 vdd well_1977 ntap1 A=4e-12 P=8e-6
MM4_187 net31 net1 vdd well_1977 sg13_lv_pmos w=1u l=1u m=1
RT1978 vdd well_1978 ntap1 A=4e-12 P=8e-6
MM4_188 net31 net1 vdd well_1978 sg13_lv_pmos w=1u l=1u m=1
RT1979 vdd well_1979 ntap1 A=4e-12 P=8e-6
MM4_189 net31 net1 vdd well_1979 sg13_lv_pmos w=1u l=1u m=1
RT1980 vdd well_1980 ntap1 A=4e-12 P=8e-6
MM4_190 net31 net1 vdd well_1980 sg13_lv_pmos w=1u l=1u m=1
RT1981 vdd well_1981 ntap1 A=4e-12 P=8e-6
MM4_191 net31 net1 vdd well_1981 sg13_lv_pmos w=1u l=1u m=1
RT1982 vdd well_1982 ntap1 A=4e-12 P=8e-6
MM4_192 net31 net1 vdd well_1982 sg13_lv_pmos w=1u l=1u m=1
RT1983 vdd well_1983 ntap1 A=4e-12 P=8e-6
MM4_193 net31 net1 vdd well_1983 sg13_lv_pmos w=1u l=1u m=1
RT1984 vdd well_1984 ntap1 A=4e-12 P=8e-6
MM4_194 net31 net1 vdd well_1984 sg13_lv_pmos w=1u l=1u m=1
RT1985 vdd well_1985 ntap1 A=4e-12 P=8e-6
MM4_195 net31 net1 vdd well_1985 sg13_lv_pmos w=1u l=1u m=1
RT1986 vdd well_1986 ntap1 A=4e-12 P=8e-6
MM4_196 net31 net1 vdd well_1986 sg13_lv_pmos w=1u l=1u m=1
RT1987 vdd well_1987 ntap1 A=4e-12 P=8e-6
MM4_197 net31 net1 vdd well_1987 sg13_lv_pmos w=1u l=1u m=1
RT1988 vdd well_1988 ntap1 A=4e-12 P=8e-6
MM4_198 net31 net1 vdd well_1988 sg13_lv_pmos w=1u l=1u m=1
RT1989 vdd well_1989 ntap1 A=4e-12 P=8e-6
MM4_199 net31 net1 vdd well_1989 sg13_lv_pmos w=1u l=1u m=1
RT1990 vdd well_1990 ntap1 A=4e-12 P=8e-6
MM4_200 net31 net1 vdd well_1990 sg13_lv_pmos w=1u l=1u m=1
RT1991 vdd well_1991 ntap1 A=4e-12 P=8e-6
MM4_201 net31 net1 vdd well_1991 sg13_lv_pmos w=1u l=1u m=1
RT1992 vdd well_1992 ntap1 A=4e-12 P=8e-6
MM4_202 net31 net1 vdd well_1992 sg13_lv_pmos w=1u l=1u m=1
RT1993 vdd well_1993 ntap1 A=4e-12 P=8e-6
MM4_203 net31 net1 vdd well_1993 sg13_lv_pmos w=1u l=1u m=1
RT1994 vdd well_1994 ntap1 A=4e-12 P=8e-6
MM4_204 net31 net1 vdd well_1994 sg13_lv_pmos w=1u l=1u m=1
RT1995 vdd well_1995 ntap1 A=4e-12 P=8e-6
MM4_205 net31 net1 vdd well_1995 sg13_lv_pmos w=1u l=1u m=1
RT1996 vdd well_1996 ntap1 A=4e-12 P=8e-6
MM4_206 net31 net1 vdd well_1996 sg13_lv_pmos w=1u l=1u m=1
RT1997 vdd well_1997 ntap1 A=4e-12 P=8e-6
MM4_207 net31 net1 vdd well_1997 sg13_lv_pmos w=1u l=1u m=1
RT1998 vdd well_1998 ntap1 A=4e-12 P=8e-6
MM4_208 net31 net1 vdd well_1998 sg13_lv_pmos w=1u l=1u m=1
RT1999 vdd well_1999 ntap1 A=4e-12 P=8e-6
MM4_209 net31 net1 vdd well_1999 sg13_lv_pmos w=1u l=1u m=1
RT2000 vdd well_2000 ntap1 A=4e-12 P=8e-6
MM4_210 net31 net1 vdd well_2000 sg13_lv_pmos w=1u l=1u m=1
RT2001 vdd well_2001 ntap1 A=4e-12 P=8e-6
MM4_211 net31 net1 vdd well_2001 sg13_lv_pmos w=1u l=1u m=1
RT2002 vdd well_2002 ntap1 A=4e-12 P=8e-6
MM4_212 net31 net1 vdd well_2002 sg13_lv_pmos w=1u l=1u m=1
RT2003 vdd well_2003 ntap1 A=4e-12 P=8e-6
MM4_213 net31 net1 vdd well_2003 sg13_lv_pmos w=1u l=1u m=1
RT2004 vdd well_2004 ntap1 A=4e-12 P=8e-6
MM4_214 net31 net1 vdd well_2004 sg13_lv_pmos w=1u l=1u m=1
RT2005 vdd well_2005 ntap1 A=4e-12 P=8e-6
MM4_215 net31 net1 vdd well_2005 sg13_lv_pmos w=1u l=1u m=1
RT2006 vdd well_2006 ntap1 A=4e-12 P=8e-6
MM4_216 net31 net1 vdd well_2006 sg13_lv_pmos w=1u l=1u m=1
RT2007 vdd well_2007 ntap1 A=4e-12 P=8e-6
MM4_217 net31 net1 vdd well_2007 sg13_lv_pmos w=1u l=1u m=1
RT2008 vdd well_2008 ntap1 A=4e-12 P=8e-6
MM4_218 net31 net1 vdd well_2008 sg13_lv_pmos w=1u l=1u m=1
RT2009 vdd well_2009 ntap1 A=4e-12 P=8e-6
MM4_219 net31 net1 vdd well_2009 sg13_lv_pmos w=1u l=1u m=1
RT2010 vdd well_2010 ntap1 A=4e-12 P=8e-6
MM4_220 net31 net1 vdd well_2010 sg13_lv_pmos w=1u l=1u m=1
RT2011 vdd well_2011 ntap1 A=4e-12 P=8e-6
MM4_221 net31 net1 vdd well_2011 sg13_lv_pmos w=1u l=1u m=1
RT2012 vdd well_2012 ntap1 A=4e-12 P=8e-6
MM4_222 net31 net1 vdd well_2012 sg13_lv_pmos w=1u l=1u m=1
RT2013 vdd well_2013 ntap1 A=4e-12 P=8e-6
MM4_223 net31 net1 vdd well_2013 sg13_lv_pmos w=1u l=1u m=1
RT2014 vdd well_2014 ntap1 A=4e-12 P=8e-6
MM4_224 net31 net1 vdd well_2014 sg13_lv_pmos w=1u l=1u m=1
RT2015 vdd well_2015 ntap1 A=4e-12 P=8e-6
MM4_225 net31 net1 vdd well_2015 sg13_lv_pmos w=1u l=1u m=1
RT2016 vdd well_2016 ntap1 A=4e-12 P=8e-6
MM4_226 net31 net1 vdd well_2016 sg13_lv_pmos w=1u l=1u m=1
RT2017 vdd well_2017 ntap1 A=4e-12 P=8e-6
MM4_227 net31 net1 vdd well_2017 sg13_lv_pmos w=1u l=1u m=1
RT2018 vdd well_2018 ntap1 A=4e-12 P=8e-6
MM4_228 net31 net1 vdd well_2018 sg13_lv_pmos w=1u l=1u m=1
RT2019 vdd well_2019 ntap1 A=4e-12 P=8e-6
MM4_229 net31 net1 vdd well_2019 sg13_lv_pmos w=1u l=1u m=1
RT2020 vdd well_2020 ntap1 A=4e-12 P=8e-6
MM4_230 net31 net1 vdd well_2020 sg13_lv_pmos w=1u l=1u m=1
RT2021 vdd well_2021 ntap1 A=4e-12 P=8e-6
MM4_231 net31 net1 vdd well_2021 sg13_lv_pmos w=1u l=1u m=1
RT2022 vdd well_2022 ntap1 A=4e-12 P=8e-6
MM4_232 net31 net1 vdd well_2022 sg13_lv_pmos w=1u l=1u m=1
RT2023 vdd well_2023 ntap1 A=4e-12 P=8e-6
MM4_233 net31 net1 vdd well_2023 sg13_lv_pmos w=1u l=1u m=1
RT2024 vdd well_2024 ntap1 A=4e-12 P=8e-6
MM4_234 net31 net1 vdd well_2024 sg13_lv_pmos w=1u l=1u m=1
RT2025 vdd well_2025 ntap1 A=4e-12 P=8e-6
MM4_235 net31 net1 vdd well_2025 sg13_lv_pmos w=1u l=1u m=1
RT2026 vdd well_2026 ntap1 A=4e-12 P=8e-6
MM4_236 net31 net1 vdd well_2026 sg13_lv_pmos w=1u l=1u m=1
RT2027 vdd well_2027 ntap1 A=4e-12 P=8e-6
MM4_237 net31 net1 vdd well_2027 sg13_lv_pmos w=1u l=1u m=1
RT2028 vdd well_2028 ntap1 A=4e-12 P=8e-6
MM4_238 net31 net1 vdd well_2028 sg13_lv_pmos w=1u l=1u m=1
RT2029 vdd well_2029 ntap1 A=4e-12 P=8e-6
MM4_239 net31 net1 vdd well_2029 sg13_lv_pmos w=1u l=1u m=1
RT2030 vdd well_2030 ntap1 A=4e-12 P=8e-6
MM4_240 net31 net1 vdd well_2030 sg13_lv_pmos w=1u l=1u m=1
RT2031 vdd well_2031 ntap1 A=4e-12 P=8e-6
MM4_241 net31 net1 vdd well_2031 sg13_lv_pmos w=1u l=1u m=1
RT2032 vdd well_2032 ntap1 A=4e-12 P=8e-6
MM4_242 net31 net1 vdd well_2032 sg13_lv_pmos w=1u l=1u m=1
RT2033 vdd well_2033 ntap1 A=4e-12 P=8e-6
MM4_243 net31 net1 vdd well_2033 sg13_lv_pmos w=1u l=1u m=1
RT2034 vdd well_2034 ntap1 A=4e-12 P=8e-6
MM4_244 net31 net1 vdd well_2034 sg13_lv_pmos w=1u l=1u m=1
RT2035 vdd well_2035 ntap1 A=4e-12 P=8e-6
MM4_245 net31 net1 vdd well_2035 sg13_lv_pmos w=1u l=1u m=1
RT2036 vdd well_2036 ntap1 A=4e-12 P=8e-6
MM4_246 net31 net1 vdd well_2036 sg13_lv_pmos w=1u l=1u m=1
RT2037 vdd well_2037 ntap1 A=4e-12 P=8e-6
MM4_247 net31 net1 vdd well_2037 sg13_lv_pmos w=1u l=1u m=1
RT2038 vdd well_2038 ntap1 A=4e-12 P=8e-6
MM4_248 net31 net1 vdd well_2038 sg13_lv_pmos w=1u l=1u m=1
RT2039 vdd well_2039 ntap1 A=4e-12 P=8e-6
MM4_249 net31 net1 vdd well_2039 sg13_lv_pmos w=1u l=1u m=1
RT2040 vdd well_2040 ntap1 A=4e-12 P=8e-6
MM4_250 net31 net1 vdd well_2040 sg13_lv_pmos w=1u l=1u m=1
RT2041 vdd well_2041 ntap1 A=4e-12 P=8e-6
MM4_251 net31 net1 vdd well_2041 sg13_lv_pmos w=1u l=1u m=1
RT2042 vdd well_2042 ntap1 A=4e-12 P=8e-6
MM4_252 net31 net1 vdd well_2042 sg13_lv_pmos w=1u l=1u m=1
RT2043 vdd well_2043 ntap1 A=4e-12 P=8e-6
MM4_253 net31 net1 vdd well_2043 sg13_lv_pmos w=1u l=1u m=1
RT2044 vdd well_2044 ntap1 A=4e-12 P=8e-6
MM4_254 net31 net1 vdd well_2044 sg13_lv_pmos w=1u l=1u m=1
RT2045 vdd well_2045 ntap1 A=4e-12 P=8e-6
MM4_255 net31 net1 vdd well_2045 sg13_lv_pmos w=1u l=1u m=1
RT2046 vdd well_2046 ntap1 A=4e-12 P=8e-6
MM4_256 net31 net1 vdd well_2046 sg13_lv_pmos w=1u l=1u m=1
RT2047 vdd well_2047 ntap1 A=4e-12 P=8e-6
MM4_257 net31 net1 vdd well_2047 sg13_lv_pmos w=1u l=1u m=1
RT2048 vdd well_2048 ntap1 A=4e-12 P=8e-6
MM4_258 net31 net1 vdd well_2048 sg13_lv_pmos w=1u l=1u m=1
RT2049 vdd well_2049 ntap1 A=4e-12 P=8e-6
MM4_259 net31 net1 vdd well_2049 sg13_lv_pmos w=1u l=1u m=1
RT2050 vdd well_2050 ntap1 A=4e-12 P=8e-6
MM4_260 net31 net1 vdd well_2050 sg13_lv_pmos w=1u l=1u m=1
RT2051 vdd well_2051 ntap1 A=4e-12 P=8e-6
MM4_261 net31 net1 vdd well_2051 sg13_lv_pmos w=1u l=1u m=1
RT2052 vdd well_2052 ntap1 A=4e-12 P=8e-6
MM4_262 net31 net1 vdd well_2052 sg13_lv_pmos w=1u l=1u m=1
RT2053 vdd well_2053 ntap1 A=4e-12 P=8e-6
MM4_263 net31 net1 vdd well_2053 sg13_lv_pmos w=1u l=1u m=1
RT2054 vdd well_2054 ntap1 A=4e-12 P=8e-6
MM4_264 net31 net1 vdd well_2054 sg13_lv_pmos w=1u l=1u m=1
RT2055 vdd well_2055 ntap1 A=4e-12 P=8e-6
MM4_265 net31 net1 vdd well_2055 sg13_lv_pmos w=1u l=1u m=1
RT2056 vdd well_2056 ntap1 A=4e-12 P=8e-6
MM4_266 net31 net1 vdd well_2056 sg13_lv_pmos w=1u l=1u m=1
RT2057 vdd well_2057 ntap1 A=4e-12 P=8e-6
MM4_267 net31 net1 vdd well_2057 sg13_lv_pmos w=1u l=1u m=1
RT2058 vdd well_2058 ntap1 A=4e-12 P=8e-6
MM4_268 net31 net1 vdd well_2058 sg13_lv_pmos w=1u l=1u m=1
RT2059 vdd well_2059 ntap1 A=4e-12 P=8e-6
MM4_269 net31 net1 vdd well_2059 sg13_lv_pmos w=1u l=1u m=1
RT2060 vdd well_2060 ntap1 A=4e-12 P=8e-6
MM4_270 net31 net1 vdd well_2060 sg13_lv_pmos w=1u l=1u m=1
RT2061 vdd well_2061 ntap1 A=4e-12 P=8e-6
MM4_271 net31 net1 vdd well_2061 sg13_lv_pmos w=1u l=1u m=1
RT2062 vdd well_2062 ntap1 A=4e-12 P=8e-6
MM4_272 net31 net1 vdd well_2062 sg13_lv_pmos w=1u l=1u m=1
RT2063 vdd well_2063 ntap1 A=4e-12 P=8e-6
MM4_273 net31 net1 vdd well_2063 sg13_lv_pmos w=1u l=1u m=1
RT2064 vdd well_2064 ntap1 A=4e-12 P=8e-6
MM4_274 net31 net1 vdd well_2064 sg13_lv_pmos w=1u l=1u m=1
RT2065 vdd well_2065 ntap1 A=4e-12 P=8e-6
MM4_275 net31 net1 vdd well_2065 sg13_lv_pmos w=1u l=1u m=1
RT2066 vdd well_2066 ntap1 A=4e-12 P=8e-6
MM4_276 net31 net1 vdd well_2066 sg13_lv_pmos w=1u l=1u m=1
RT2067 vdd well_2067 ntap1 A=4e-12 P=8e-6
MM4_277 net31 net1 vdd well_2067 sg13_lv_pmos w=1u l=1u m=1
RT2068 vdd well_2068 ntap1 A=4e-12 P=8e-6
MM4_278 net31 net1 vdd well_2068 sg13_lv_pmos w=1u l=1u m=1
RT2069 vdd well_2069 ntap1 A=4e-12 P=8e-6
MM4_279 net31 net1 vdd well_2069 sg13_lv_pmos w=1u l=1u m=1
RT2070 vdd well_2070 ntap1 A=4e-12 P=8e-6
MM4_280 net31 net1 vdd well_2070 sg13_lv_pmos w=1u l=1u m=1
RT2071 vdd well_2071 ntap1 A=4e-12 P=8e-6
MM4_281 net31 net1 vdd well_2071 sg13_lv_pmos w=1u l=1u m=1
RT2072 vdd well_2072 ntap1 A=4e-12 P=8e-6
MM4_282 net31 net1 vdd well_2072 sg13_lv_pmos w=1u l=1u m=1
RT2073 vdd well_2073 ntap1 A=4e-12 P=8e-6
MM4_283 net31 net1 vdd well_2073 sg13_lv_pmos w=1u l=1u m=1
RT2074 vdd well_2074 ntap1 A=4e-12 P=8e-6
MM5_0 voutn voutn vdd well_2074 sg13_lv_pmos w=1u l=1u m=1
RT2075 vdd well_2075 ntap1 A=4e-12 P=8e-6
MM5_1 voutn voutn vdd well_2075 sg13_lv_pmos w=1u l=1u m=1
RT2076 vdd well_2076 ntap1 A=4e-12 P=8e-6
MM5_2 voutn voutn vdd well_2076 sg13_lv_pmos w=1u l=1u m=1
RT2077 vdd well_2077 ntap1 A=4e-12 P=8e-6
MM5_3 voutn voutn vdd well_2077 sg13_lv_pmos w=1u l=1u m=1
RT2078 vdd well_2078 ntap1 A=4e-12 P=8e-6
MM5_4 voutn voutn vdd well_2078 sg13_lv_pmos w=1u l=1u m=1
RT2079 vdd well_2079 ntap1 A=4e-12 P=8e-6
MM5_5 voutn voutn vdd well_2079 sg13_lv_pmos w=1u l=1u m=1
RT2080 vdd well_2080 ntap1 A=4e-12 P=8e-6
MM5_6 voutn voutn vdd well_2080 sg13_lv_pmos w=1u l=1u m=1
RT2081 vdd well_2081 ntap1 A=4e-12 P=8e-6
MM5_7 voutn voutn vdd well_2081 sg13_lv_pmos w=1u l=1u m=1
RT2082 vdd well_2082 ntap1 A=4e-12 P=8e-6
MM5_8 voutn voutn vdd well_2082 sg13_lv_pmos w=1u l=1u m=1
RT2083 vdd well_2083 ntap1 A=4e-12 P=8e-6
MM5_9 voutn voutn vdd well_2083 sg13_lv_pmos w=1u l=1u m=1
RT2084 vdd well_2084 ntap1 A=4e-12 P=8e-6
MM5_10 voutn voutn vdd well_2084 sg13_lv_pmos w=1u l=1u m=1
RT2085 vdd well_2085 ntap1 A=4e-12 P=8e-6
MM5_11 voutn voutn vdd well_2085 sg13_lv_pmos w=1u l=1u m=1
RT2086 vdd well_2086 ntap1 A=4e-12 P=8e-6
MM5_12 voutn voutn vdd well_2086 sg13_lv_pmos w=1u l=1u m=1
RT2087 vdd well_2087 ntap1 A=4e-12 P=8e-6
MM5_13 voutn voutn vdd well_2087 sg13_lv_pmos w=1u l=1u m=1
RT2088 vdd well_2088 ntap1 A=4e-12 P=8e-6
MM5_14 voutn voutn vdd well_2088 sg13_lv_pmos w=1u l=1u m=1
RT2089 vdd well_2089 ntap1 A=4e-12 P=8e-6
MM5_15 voutn voutn vdd well_2089 sg13_lv_pmos w=1u l=1u m=1
RT2090 vdd well_2090 ntap1 A=4e-12 P=8e-6
MM5_16 voutn voutn vdd well_2090 sg13_lv_pmos w=1u l=1u m=1
RT2091 vdd well_2091 ntap1 A=4e-12 P=8e-6
MM5_17 voutn voutn vdd well_2091 sg13_lv_pmos w=1u l=1u m=1
RT2092 vdd well_2092 ntap1 A=4e-12 P=8e-6
MM5_18 voutn voutn vdd well_2092 sg13_lv_pmos w=1u l=1u m=1
RT2093 vdd well_2093 ntap1 A=4e-12 P=8e-6
MM5_19 voutn voutn vdd well_2093 sg13_lv_pmos w=1u l=1u m=1
RT2094 vdd well_2094 ntap1 A=4e-12 P=8e-6
MM5_20 voutn voutn vdd well_2094 sg13_lv_pmos w=1u l=1u m=1
RT2095 vdd well_2095 ntap1 A=4e-12 P=8e-6
MM5_21 voutn voutn vdd well_2095 sg13_lv_pmos w=1u l=1u m=1
RT2096 vdd well_2096 ntap1 A=4e-12 P=8e-6
MM5_22 voutn voutn vdd well_2096 sg13_lv_pmos w=1u l=1u m=1
RT2097 vdd well_2097 ntap1 A=4e-12 P=8e-6
MM5_23 voutn voutn vdd well_2097 sg13_lv_pmos w=1u l=1u m=1
RT2098 vdd well_2098 ntap1 A=4e-12 P=8e-6
MM5_24 voutn voutn vdd well_2098 sg13_lv_pmos w=1u l=1u m=1
RT2099 vdd well_2099 ntap1 A=4e-12 P=8e-6
MM5_25 voutn voutn vdd well_2099 sg13_lv_pmos w=1u l=1u m=1
RT2100 vdd well_2100 ntap1 A=4e-12 P=8e-6
MM5_26 voutn voutn vdd well_2100 sg13_lv_pmos w=1u l=1u m=1
RT2101 vdd well_2101 ntap1 A=4e-12 P=8e-6
MM5_27 voutn voutn vdd well_2101 sg13_lv_pmos w=1u l=1u m=1
RT2102 vdd well_2102 ntap1 A=4e-12 P=8e-6
MM5_28 voutn voutn vdd well_2102 sg13_lv_pmos w=1u l=1u m=1
RT2103 vdd well_2103 ntap1 A=4e-12 P=8e-6
MM5_29 voutn voutn vdd well_2103 sg13_lv_pmos w=1u l=1u m=1
RT2104 vdd well_2104 ntap1 A=4e-12 P=8e-6
MM5_30 voutn voutn vdd well_2104 sg13_lv_pmos w=1u l=1u m=1
RT2105 vdd well_2105 ntap1 A=4e-12 P=8e-6
MM5_31 voutn voutn vdd well_2105 sg13_lv_pmos w=1u l=1u m=1
RT2106 vdd well_2106 ntap1 A=4e-12 P=8e-6
MM5_32 voutn voutn vdd well_2106 sg13_lv_pmos w=1u l=1u m=1
RT2107 vdd well_2107 ntap1 A=4e-12 P=8e-6
MM5_33 voutn voutn vdd well_2107 sg13_lv_pmos w=1u l=1u m=1
RT2108 vdd well_2108 ntap1 A=4e-12 P=8e-6
MM5_34 voutn voutn vdd well_2108 sg13_lv_pmos w=1u l=1u m=1
RT2109 vdd well_2109 ntap1 A=4e-12 P=8e-6
MM5_35 voutn voutn vdd well_2109 sg13_lv_pmos w=1u l=1u m=1
RT2110 vdd well_2110 ntap1 A=4e-12 P=8e-6
MM5_36 voutn voutn vdd well_2110 sg13_lv_pmos w=1u l=1u m=1
RT2111 vdd well_2111 ntap1 A=4e-12 P=8e-6
MM5_37 voutn voutn vdd well_2111 sg13_lv_pmos w=1u l=1u m=1
RT2112 vdd well_2112 ntap1 A=4e-12 P=8e-6
MM5_38 voutn voutn vdd well_2112 sg13_lv_pmos w=1u l=1u m=1
RT2113 vdd well_2113 ntap1 A=4e-12 P=8e-6
MM5_39 voutn voutn vdd well_2113 sg13_lv_pmos w=1u l=1u m=1
RT2114 vdd well_2114 ntap1 A=4e-12 P=8e-6
MM5_40 voutn voutn vdd well_2114 sg13_lv_pmos w=1u l=1u m=1
RT2115 vdd well_2115 ntap1 A=4e-12 P=8e-6
MM5_41 voutn voutn vdd well_2115 sg13_lv_pmos w=1u l=1u m=1
RT2116 vdd well_2116 ntap1 A=4e-12 P=8e-6
MM5_42 voutn voutn vdd well_2116 sg13_lv_pmos w=1u l=1u m=1
RT2117 vdd well_2117 ntap1 A=4e-12 P=8e-6
MM5_43 voutn voutn vdd well_2117 sg13_lv_pmos w=1u l=1u m=1
RT2118 vdd well_2118 ntap1 A=4e-12 P=8e-6
MM5_44 voutn voutn vdd well_2118 sg13_lv_pmos w=1u l=1u m=1
RT2119 vdd well_2119 ntap1 A=4e-12 P=8e-6
MM5_45 voutn voutn vdd well_2119 sg13_lv_pmos w=1u l=1u m=1
RT2120 vdd well_2120 ntap1 A=4e-12 P=8e-6
MM5_46 voutn voutn vdd well_2120 sg13_lv_pmos w=1u l=1u m=1
RT2121 vdd well_2121 ntap1 A=4e-12 P=8e-6
MM5_47 voutn voutn vdd well_2121 sg13_lv_pmos w=1u l=1u m=1
RT2122 vdd well_2122 ntap1 A=4e-12 P=8e-6
MM5_48 voutn voutn vdd well_2122 sg13_lv_pmos w=1u l=1u m=1
RT2123 vdd well_2123 ntap1 A=4e-12 P=8e-6
MM5_49 voutn voutn vdd well_2123 sg13_lv_pmos w=1u l=1u m=1
RT2124 vdd well_2124 ntap1 A=4e-12 P=8e-6
MM5_50 voutn voutn vdd well_2124 sg13_lv_pmos w=1u l=1u m=1
RT2125 vdd well_2125 ntap1 A=4e-12 P=8e-6
MM5_51 voutn voutn vdd well_2125 sg13_lv_pmos w=1u l=1u m=1
RT2126 vdd well_2126 ntap1 A=4e-12 P=8e-6
MM5_52 voutn voutn vdd well_2126 sg13_lv_pmos w=1u l=1u m=1
RT2127 vdd well_2127 ntap1 A=4e-12 P=8e-6
MM5_53 voutn voutn vdd well_2127 sg13_lv_pmos w=1u l=1u m=1
RT2128 vdd well_2128 ntap1 A=4e-12 P=8e-6
MM5_54 voutn voutn vdd well_2128 sg13_lv_pmos w=1u l=1u m=1
RT2129 vdd well_2129 ntap1 A=4e-12 P=8e-6
MM5_55 voutn voutn vdd well_2129 sg13_lv_pmos w=1u l=1u m=1
RT2130 vdd well_2130 ntap1 A=4e-12 P=8e-6
MM5_56 voutn voutn vdd well_2130 sg13_lv_pmos w=1u l=1u m=1
RT2131 vdd well_2131 ntap1 A=4e-12 P=8e-6
MM5_57 voutn voutn vdd well_2131 sg13_lv_pmos w=1u l=1u m=1
RT2132 vdd well_2132 ntap1 A=4e-12 P=8e-6
MM5_58 voutn voutn vdd well_2132 sg13_lv_pmos w=1u l=1u m=1
RT2133 vdd well_2133 ntap1 A=4e-12 P=8e-6
MM5_59 voutn voutn vdd well_2133 sg13_lv_pmos w=1u l=1u m=1
RT2134 vdd well_2134 ntap1 A=4e-12 P=8e-6
MM5_60 voutn voutn vdd well_2134 sg13_lv_pmos w=1u l=1u m=1
RT2135 vdd well_2135 ntap1 A=4e-12 P=8e-6
MM5_61 voutn voutn vdd well_2135 sg13_lv_pmos w=1u l=1u m=1
RT2136 vdd well_2136 ntap1 A=4e-12 P=8e-6
MM5_62 voutn voutn vdd well_2136 sg13_lv_pmos w=1u l=1u m=1
RT2137 vdd well_2137 ntap1 A=4e-12 P=8e-6
MM5_63 voutn voutn vdd well_2137 sg13_lv_pmos w=1u l=1u m=1
RT2138 vdd well_2138 ntap1 A=4e-12 P=8e-6
MM5_64 voutn voutn vdd well_2138 sg13_lv_pmos w=1u l=1u m=1
RT2139 vdd well_2139 ntap1 A=4e-12 P=8e-6
MM5_65 voutn voutn vdd well_2139 sg13_lv_pmos w=1u l=1u m=1
RT2140 vdd well_2140 ntap1 A=4e-12 P=8e-6
MM5_66 voutn voutn vdd well_2140 sg13_lv_pmos w=1u l=1u m=1
RT2141 vdd well_2141 ntap1 A=4e-12 P=8e-6
MM5_67 voutn voutn vdd well_2141 sg13_lv_pmos w=1u l=1u m=1
RT2142 vdd well_2142 ntap1 A=4e-12 P=8e-6
MM5_68 voutn voutn vdd well_2142 sg13_lv_pmos w=1u l=1u m=1
RT2143 vdd well_2143 ntap1 A=4e-12 P=8e-6
MM5_69 voutn voutn vdd well_2143 sg13_lv_pmos w=1u l=1u m=1
RT2144 vdd well_2144 ntap1 A=4e-12 P=8e-6
MM5_70 voutn voutn vdd well_2144 sg13_lv_pmos w=1u l=1u m=1
RT2145 vdd well_2145 ntap1 A=4e-12 P=8e-6
MM6_0 net050 voutn vdd well_2145 sg13_lv_pmos w=1u l=1u m=1
RT2146 vdd well_2146 ntap1 A=4e-12 P=8e-6
MM6_1 net050 voutn vdd well_2146 sg13_lv_pmos w=1u l=1u m=1
RT2147 vdd well_2147 ntap1 A=4e-12 P=8e-6
MM6_2 net050 voutn vdd well_2147 sg13_lv_pmos w=1u l=1u m=1
RT2148 vdd well_2148 ntap1 A=4e-12 P=8e-6
MM6_3 net050 voutn vdd well_2148 sg13_lv_pmos w=1u l=1u m=1
RT2149 vdd well_2149 ntap1 A=4e-12 P=8e-6
MM6_4 net050 voutn vdd well_2149 sg13_lv_pmos w=1u l=1u m=1
RT2150 vdd well_2150 ntap1 A=4e-12 P=8e-6
MM6_5 net050 voutn vdd well_2150 sg13_lv_pmos w=1u l=1u m=1
RT2151 vdd well_2151 ntap1 A=4e-12 P=8e-6
MM6_6 net050 voutn vdd well_2151 sg13_lv_pmos w=1u l=1u m=1
RT2152 vdd well_2152 ntap1 A=4e-12 P=8e-6
MM6_7 net050 voutn vdd well_2152 sg13_lv_pmos w=1u l=1u m=1
RT2153 vdd well_2153 ntap1 A=4e-12 P=8e-6
MM6_8 net050 voutn vdd well_2153 sg13_lv_pmos w=1u l=1u m=1
RT2154 vdd well_2154 ntap1 A=4e-12 P=8e-6
MM6_9 net050 voutn vdd well_2154 sg13_lv_pmos w=1u l=1u m=1
RT2155 vdd well_2155 ntap1 A=4e-12 P=8e-6
MM6_10 net050 voutn vdd well_2155 sg13_lv_pmos w=1u l=1u m=1
RT2156 vdd well_2156 ntap1 A=4e-12 P=8e-6
MM6_11 net050 voutn vdd well_2156 sg13_lv_pmos w=1u l=1u m=1
RT2157 vdd well_2157 ntap1 A=4e-12 P=8e-6
MM6_12 net050 voutn vdd well_2157 sg13_lv_pmos w=1u l=1u m=1
RT2158 vdd well_2158 ntap1 A=4e-12 P=8e-6
MM6_13 net050 voutn vdd well_2158 sg13_lv_pmos w=1u l=1u m=1
RT2159 vdd well_2159 ntap1 A=4e-12 P=8e-6
MM6_14 net050 voutn vdd well_2159 sg13_lv_pmos w=1u l=1u m=1
RT2160 vdd well_2160 ntap1 A=4e-12 P=8e-6
MM6_15 net050 voutn vdd well_2160 sg13_lv_pmos w=1u l=1u m=1
RT2161 vdd well_2161 ntap1 A=4e-12 P=8e-6
MM6_16 net050 voutn vdd well_2161 sg13_lv_pmos w=1u l=1u m=1
RT2162 vdd well_2162 ntap1 A=4e-12 P=8e-6
MM6_17 net050 voutn vdd well_2162 sg13_lv_pmos w=1u l=1u m=1
RT2163 vdd well_2163 ntap1 A=4e-12 P=8e-6
MM6_18 net050 voutn vdd well_2163 sg13_lv_pmos w=1u l=1u m=1
RT2164 vdd well_2164 ntap1 A=4e-12 P=8e-6
MM6_19 net050 voutn vdd well_2164 sg13_lv_pmos w=1u l=1u m=1
RT2165 vdd well_2165 ntap1 A=4e-12 P=8e-6
MM6_20 net050 voutn vdd well_2165 sg13_lv_pmos w=1u l=1u m=1
RT2166 vdd well_2166 ntap1 A=4e-12 P=8e-6
MM6_21 net050 voutn vdd well_2166 sg13_lv_pmos w=1u l=1u m=1
RT2167 vdd well_2167 ntap1 A=4e-12 P=8e-6
MM6_22 net050 voutn vdd well_2167 sg13_lv_pmos w=1u l=1u m=1
RT2168 vdd well_2168 ntap1 A=4e-12 P=8e-6
MM6_23 net050 voutn vdd well_2168 sg13_lv_pmos w=1u l=1u m=1
RT2169 vdd well_2169 ntap1 A=4e-12 P=8e-6
MM6_24 net050 voutn vdd well_2169 sg13_lv_pmos w=1u l=1u m=1
RT2170 vdd well_2170 ntap1 A=4e-12 P=8e-6
MM6_25 net050 voutn vdd well_2170 sg13_lv_pmos w=1u l=1u m=1
RT2171 vdd well_2171 ntap1 A=4e-12 P=8e-6
MM6_26 net050 voutn vdd well_2171 sg13_lv_pmos w=1u l=1u m=1
RT2172 vdd well_2172 ntap1 A=4e-12 P=8e-6
MM6_27 net050 voutn vdd well_2172 sg13_lv_pmos w=1u l=1u m=1
RT2173 vdd well_2173 ntap1 A=4e-12 P=8e-6
MM6_28 net050 voutn vdd well_2173 sg13_lv_pmos w=1u l=1u m=1
RT2174 vdd well_2174 ntap1 A=4e-12 P=8e-6
MM6_29 net050 voutn vdd well_2174 sg13_lv_pmos w=1u l=1u m=1
RT2175 vdd well_2175 ntap1 A=4e-12 P=8e-6
MM6_30 net050 voutn vdd well_2175 sg13_lv_pmos w=1u l=1u m=1
RT2176 vdd well_2176 ntap1 A=4e-12 P=8e-6
MM6_31 net050 voutn vdd well_2176 sg13_lv_pmos w=1u l=1u m=1
RT2177 vdd well_2177 ntap1 A=4e-12 P=8e-6
MM6_32 net050 voutn vdd well_2177 sg13_lv_pmos w=1u l=1u m=1
RT2178 vdd well_2178 ntap1 A=4e-12 P=8e-6
MM6_33 net050 voutn vdd well_2178 sg13_lv_pmos w=1u l=1u m=1
RT2179 vdd well_2179 ntap1 A=4e-12 P=8e-6
MM6_34 net050 voutn vdd well_2179 sg13_lv_pmos w=1u l=1u m=1
RT2180 vdd well_2180 ntap1 A=4e-12 P=8e-6
MM6_35 net050 voutn vdd well_2180 sg13_lv_pmos w=1u l=1u m=1
RT2181 vdd well_2181 ntap1 A=4e-12 P=8e-6
MM6_36 net050 voutn vdd well_2181 sg13_lv_pmos w=1u l=1u m=1
RT2182 vdd well_2182 ntap1 A=4e-12 P=8e-6
MM6_37 net050 voutn vdd well_2182 sg13_lv_pmos w=1u l=1u m=1
RT2183 vdd well_2183 ntap1 A=4e-12 P=8e-6
MM6_38 net050 voutn vdd well_2183 sg13_lv_pmos w=1u l=1u m=1
RT2184 vdd well_2184 ntap1 A=4e-12 P=8e-6
MM6_39 net050 voutn vdd well_2184 sg13_lv_pmos w=1u l=1u m=1
RT2185 vdd well_2185 ntap1 A=4e-12 P=8e-6
MM6_40 net050 voutn vdd well_2185 sg13_lv_pmos w=1u l=1u m=1
RT2186 vdd well_2186 ntap1 A=4e-12 P=8e-6
MM6_41 net050 voutn vdd well_2186 sg13_lv_pmos w=1u l=1u m=1
RT2187 vdd well_2187 ntap1 A=4e-12 P=8e-6
MM6_42 net050 voutn vdd well_2187 sg13_lv_pmos w=1u l=1u m=1
RT2188 vdd well_2188 ntap1 A=4e-12 P=8e-6
MM6_43 net050 voutn vdd well_2188 sg13_lv_pmos w=1u l=1u m=1
RT2189 vdd well_2189 ntap1 A=4e-12 P=8e-6
MM6_44 net050 voutn vdd well_2189 sg13_lv_pmos w=1u l=1u m=1
RT2190 vdd well_2190 ntap1 A=4e-12 P=8e-6
MM6_45 net050 voutn vdd well_2190 sg13_lv_pmos w=1u l=1u m=1
RT2191 vdd well_2191 ntap1 A=4e-12 P=8e-6
MM6_46 net050 voutn vdd well_2191 sg13_lv_pmos w=1u l=1u m=1
RT2192 vdd well_2192 ntap1 A=4e-12 P=8e-6
MM6_47 net050 voutn vdd well_2192 sg13_lv_pmos w=1u l=1u m=1
RT2193 vdd well_2193 ntap1 A=4e-12 P=8e-6
MM6_48 net050 voutn vdd well_2193 sg13_lv_pmos w=1u l=1u m=1
RT2194 vdd well_2194 ntap1 A=4e-12 P=8e-6
MM6_49 net050 voutn vdd well_2194 sg13_lv_pmos w=1u l=1u m=1
RT2195 vdd well_2195 ntap1 A=4e-12 P=8e-6
MM6_50 net050 voutn vdd well_2195 sg13_lv_pmos w=1u l=1u m=1
RT2196 vdd well_2196 ntap1 A=4e-12 P=8e-6
MM6_51 net050 voutn vdd well_2196 sg13_lv_pmos w=1u l=1u m=1
RT2197 vdd well_2197 ntap1 A=4e-12 P=8e-6
MM6_52 net050 voutn vdd well_2197 sg13_lv_pmos w=1u l=1u m=1
RT2198 vdd well_2198 ntap1 A=4e-12 P=8e-6
MM6_53 net050 voutn vdd well_2198 sg13_lv_pmos w=1u l=1u m=1
RT2199 vdd well_2199 ntap1 A=4e-12 P=8e-6
MM6_54 net050 voutn vdd well_2199 sg13_lv_pmos w=1u l=1u m=1
RT2200 vdd well_2200 ntap1 A=4e-12 P=8e-6
MM6_55 net050 voutn vdd well_2200 sg13_lv_pmos w=1u l=1u m=1
RT2201 vdd well_2201 ntap1 A=4e-12 P=8e-6
MM6_56 net050 voutn vdd well_2201 sg13_lv_pmos w=1u l=1u m=1
RT2202 vdd well_2202 ntap1 A=4e-12 P=8e-6
MM6_57 net050 voutn vdd well_2202 sg13_lv_pmos w=1u l=1u m=1
RT2203 vdd well_2203 ntap1 A=4e-12 P=8e-6
MM6_58 net050 voutn vdd well_2203 sg13_lv_pmos w=1u l=1u m=1
RT2204 vdd well_2204 ntap1 A=4e-12 P=8e-6
MM6_59 net050 voutn vdd well_2204 sg13_lv_pmos w=1u l=1u m=1
RT2205 vdd well_2205 ntap1 A=4e-12 P=8e-6
MM6_60 net050 voutn vdd well_2205 sg13_lv_pmos w=1u l=1u m=1
RT2206 vdd well_2206 ntap1 A=4e-12 P=8e-6
MM6_61 net050 voutn vdd well_2206 sg13_lv_pmos w=1u l=1u m=1
RT2207 vdd well_2207 ntap1 A=4e-12 P=8e-6
MM6_62 net050 voutn vdd well_2207 sg13_lv_pmos w=1u l=1u m=1
RT2208 vdd well_2208 ntap1 A=4e-12 P=8e-6
MM6_63 net050 voutn vdd well_2208 sg13_lv_pmos w=1u l=1u m=1
RT2209 vdd well_2209 ntap1 A=4e-12 P=8e-6
MM6_64 net050 voutn vdd well_2209 sg13_lv_pmos w=1u l=1u m=1
RT2210 vdd well_2210 ntap1 A=4e-12 P=8e-6
MM6_65 net050 voutn vdd well_2210 sg13_lv_pmos w=1u l=1u m=1
RT2211 vdd well_2211 ntap1 A=4e-12 P=8e-6
MM6_66 net050 voutn vdd well_2211 sg13_lv_pmos w=1u l=1u m=1
RT2212 vdd well_2212 ntap1 A=4e-12 P=8e-6
MM6_67 net050 voutn vdd well_2212 sg13_lv_pmos w=1u l=1u m=1
RT2213 vdd well_2213 ntap1 A=4e-12 P=8e-6
MM6_68 net050 voutn vdd well_2213 sg13_lv_pmos w=1u l=1u m=1
RT2214 vdd well_2214 ntap1 A=4e-12 P=8e-6
MM6_69 net050 voutn vdd well_2214 sg13_lv_pmos w=1u l=1u m=1
RT2215 vdd well_2215 ntap1 A=4e-12 P=8e-6
MM6_70 net050 voutn vdd well_2215 sg13_lv_pmos w=1u l=1u m=1
RT2216 vdd well_2216 ntap1 A=4e-12 P=8e-6
MM7_0 net049 net1 vdd well_2216 sg13_lv_pmos w=1u l=1u m=1
RT2217 vdd well_2217 ntap1 A=4e-12 P=8e-6
MM7_1 net049 net1 vdd well_2217 sg13_lv_pmos w=1u l=1u m=1
RT2218 vdd well_2218 ntap1 A=4e-12 P=8e-6
MM7_2 net049 net1 vdd well_2218 sg13_lv_pmos w=1u l=1u m=1
RT2219 vdd well_2219 ntap1 A=4e-12 P=8e-6
MM7_3 net049 net1 vdd well_2219 sg13_lv_pmos w=1u l=1u m=1
RT2220 vdd well_2220 ntap1 A=4e-12 P=8e-6
MM7_4 net049 net1 vdd well_2220 sg13_lv_pmos w=1u l=1u m=1
RT2221 vdd well_2221 ntap1 A=4e-12 P=8e-6
MM7_5 net049 net1 vdd well_2221 sg13_lv_pmos w=1u l=1u m=1
RT2222 vdd well_2222 ntap1 A=4e-12 P=8e-6
MM7_6 net049 net1 vdd well_2222 sg13_lv_pmos w=1u l=1u m=1
RT2223 vdd well_2223 ntap1 A=4e-12 P=8e-6
MM7_7 net049 net1 vdd well_2223 sg13_lv_pmos w=1u l=1u m=1
RT2224 vdd well_2224 ntap1 A=4e-12 P=8e-6
MM7_8 net049 net1 vdd well_2224 sg13_lv_pmos w=1u l=1u m=1
RT2225 vdd well_2225 ntap1 A=4e-12 P=8e-6
MM7_9 net049 net1 vdd well_2225 sg13_lv_pmos w=1u l=1u m=1
RT2226 vdd well_2226 ntap1 A=4e-12 P=8e-6
MM7_10 net049 net1 vdd well_2226 sg13_lv_pmos w=1u l=1u m=1
RT2227 vdd well_2227 ntap1 A=4e-12 P=8e-6
MM7_11 net049 net1 vdd well_2227 sg13_lv_pmos w=1u l=1u m=1
RT2228 vdd well_2228 ntap1 A=4e-12 P=8e-6
MM7_12 net049 net1 vdd well_2228 sg13_lv_pmos w=1u l=1u m=1
RT2229 vdd well_2229 ntap1 A=4e-12 P=8e-6
MM7_13 net049 net1 vdd well_2229 sg13_lv_pmos w=1u l=1u m=1
RT2230 vdd well_2230 ntap1 A=4e-12 P=8e-6
MM7_14 net049 net1 vdd well_2230 sg13_lv_pmos w=1u l=1u m=1
RT2231 vdd well_2231 ntap1 A=4e-12 P=8e-6
MM7_15 net049 net1 vdd well_2231 sg13_lv_pmos w=1u l=1u m=1
RT2232 vdd well_2232 ntap1 A=4e-12 P=8e-6
MM7_16 net049 net1 vdd well_2232 sg13_lv_pmos w=1u l=1u m=1
RT2233 vdd well_2233 ntap1 A=4e-12 P=8e-6
MM7_17 net049 net1 vdd well_2233 sg13_lv_pmos w=1u l=1u m=1
RT2234 vdd well_2234 ntap1 A=4e-12 P=8e-6
MM7_18 net049 net1 vdd well_2234 sg13_lv_pmos w=1u l=1u m=1
RT2235 vdd well_2235 ntap1 A=4e-12 P=8e-6
MM7_19 net049 net1 vdd well_2235 sg13_lv_pmos w=1u l=1u m=1
RT2236 vdd well_2236 ntap1 A=4e-12 P=8e-6
MM7_20 net049 net1 vdd well_2236 sg13_lv_pmos w=1u l=1u m=1
RT2237 vdd well_2237 ntap1 A=4e-12 P=8e-6
MM7_21 net049 net1 vdd well_2237 sg13_lv_pmos w=1u l=1u m=1
RT2238 vdd well_2238 ntap1 A=4e-12 P=8e-6
MM7_22 net049 net1 vdd well_2238 sg13_lv_pmos w=1u l=1u m=1
RT2239 vdd well_2239 ntap1 A=4e-12 P=8e-6
MM7_23 net049 net1 vdd well_2239 sg13_lv_pmos w=1u l=1u m=1
RT2240 vdd well_2240 ntap1 A=4e-12 P=8e-6
MM7_24 net049 net1 vdd well_2240 sg13_lv_pmos w=1u l=1u m=1
RT2241 vdd well_2241 ntap1 A=4e-12 P=8e-6
MM7_25 net049 net1 vdd well_2241 sg13_lv_pmos w=1u l=1u m=1
RT2242 vdd well_2242 ntap1 A=4e-12 P=8e-6
MM7_26 net049 net1 vdd well_2242 sg13_lv_pmos w=1u l=1u m=1
RT2243 vdd well_2243 ntap1 A=4e-12 P=8e-6
MM7_27 net049 net1 vdd well_2243 sg13_lv_pmos w=1u l=1u m=1
RT2244 vdd well_2244 ntap1 A=4e-12 P=8e-6
MM7_28 net049 net1 vdd well_2244 sg13_lv_pmos w=1u l=1u m=1
RT2245 vdd well_2245 ntap1 A=4e-12 P=8e-6
MM7_29 net049 net1 vdd well_2245 sg13_lv_pmos w=1u l=1u m=1
RT2246 vdd well_2246 ntap1 A=4e-12 P=8e-6
MM7_30 net049 net1 vdd well_2246 sg13_lv_pmos w=1u l=1u m=1
RT2247 vdd well_2247 ntap1 A=4e-12 P=8e-6
MM7_31 net049 net1 vdd well_2247 sg13_lv_pmos w=1u l=1u m=1
RT2248 vdd well_2248 ntap1 A=4e-12 P=8e-6
MM7_32 net049 net1 vdd well_2248 sg13_lv_pmos w=1u l=1u m=1
RT2249 vdd well_2249 ntap1 A=4e-12 P=8e-6
MM7_33 net049 net1 vdd well_2249 sg13_lv_pmos w=1u l=1u m=1
RT2250 vdd well_2250 ntap1 A=4e-12 P=8e-6
MM7_34 net049 net1 vdd well_2250 sg13_lv_pmos w=1u l=1u m=1
RT2251 vdd well_2251 ntap1 A=4e-12 P=8e-6
MM7_35 net049 net1 vdd well_2251 sg13_lv_pmos w=1u l=1u m=1
RT2252 vdd well_2252 ntap1 A=4e-12 P=8e-6
MM7_36 net049 net1 vdd well_2252 sg13_lv_pmos w=1u l=1u m=1
RT2253 vdd well_2253 ntap1 A=4e-12 P=8e-6
MM7_37 net049 net1 vdd well_2253 sg13_lv_pmos w=1u l=1u m=1
RT2254 vdd well_2254 ntap1 A=4e-12 P=8e-6
MM7_38 net049 net1 vdd well_2254 sg13_lv_pmos w=1u l=1u m=1
RT2255 vdd well_2255 ntap1 A=4e-12 P=8e-6
MM7_39 net049 net1 vdd well_2255 sg13_lv_pmos w=1u l=1u m=1
RT2256 vdd well_2256 ntap1 A=4e-12 P=8e-6
MM7_40 net049 net1 vdd well_2256 sg13_lv_pmos w=1u l=1u m=1
RT2257 vdd well_2257 ntap1 A=4e-12 P=8e-6
MM7_41 net049 net1 vdd well_2257 sg13_lv_pmos w=1u l=1u m=1
RT2258 vdd well_2258 ntap1 A=4e-12 P=8e-6
MM7_42 net049 net1 vdd well_2258 sg13_lv_pmos w=1u l=1u m=1
RT2259 vdd well_2259 ntap1 A=4e-12 P=8e-6
MM7_43 net049 net1 vdd well_2259 sg13_lv_pmos w=1u l=1u m=1
RT2260 vdd well_2260 ntap1 A=4e-12 P=8e-6
MM7_44 net049 net1 vdd well_2260 sg13_lv_pmos w=1u l=1u m=1
RT2261 vdd well_2261 ntap1 A=4e-12 P=8e-6
MM7_45 net049 net1 vdd well_2261 sg13_lv_pmos w=1u l=1u m=1
RT2262 vdd well_2262 ntap1 A=4e-12 P=8e-6
MM7_46 net049 net1 vdd well_2262 sg13_lv_pmos w=1u l=1u m=1
RT2263 vdd well_2263 ntap1 A=4e-12 P=8e-6
MM7_47 net049 net1 vdd well_2263 sg13_lv_pmos w=1u l=1u m=1
RT2264 vdd well_2264 ntap1 A=4e-12 P=8e-6
MM7_48 net049 net1 vdd well_2264 sg13_lv_pmos w=1u l=1u m=1
RT2265 vdd well_2265 ntap1 A=4e-12 P=8e-6
MM7_49 net049 net1 vdd well_2265 sg13_lv_pmos w=1u l=1u m=1
RT2266 vdd well_2266 ntap1 A=4e-12 P=8e-6
MM7_50 net049 net1 vdd well_2266 sg13_lv_pmos w=1u l=1u m=1
RT2267 vdd well_2267 ntap1 A=4e-12 P=8e-6
MM7_51 net049 net1 vdd well_2267 sg13_lv_pmos w=1u l=1u m=1
RT2268 vdd well_2268 ntap1 A=4e-12 P=8e-6
MM7_52 net049 net1 vdd well_2268 sg13_lv_pmos w=1u l=1u m=1
RT2269 vdd well_2269 ntap1 A=4e-12 P=8e-6
MM7_53 net049 net1 vdd well_2269 sg13_lv_pmos w=1u l=1u m=1
RT2270 vdd well_2270 ntap1 A=4e-12 P=8e-6
MM7_54 net049 net1 vdd well_2270 sg13_lv_pmos w=1u l=1u m=1
RT2271 vdd well_2271 ntap1 A=4e-12 P=8e-6
MM7_55 net049 net1 vdd well_2271 sg13_lv_pmos w=1u l=1u m=1
RT2272 vdd well_2272 ntap1 A=4e-12 P=8e-6
MM7_56 net049 net1 vdd well_2272 sg13_lv_pmos w=1u l=1u m=1
RT2273 vdd well_2273 ntap1 A=4e-12 P=8e-6
MM7_57 net049 net1 vdd well_2273 sg13_lv_pmos w=1u l=1u m=1
RT2274 vdd well_2274 ntap1 A=4e-12 P=8e-6
MM7_58 net049 net1 vdd well_2274 sg13_lv_pmos w=1u l=1u m=1
RT2275 vdd well_2275 ntap1 A=4e-12 P=8e-6
MM7_59 net049 net1 vdd well_2275 sg13_lv_pmos w=1u l=1u m=1
RT2276 vdd well_2276 ntap1 A=4e-12 P=8e-6
MM7_60 net049 net1 vdd well_2276 sg13_lv_pmos w=1u l=1u m=1
RT2277 vdd well_2277 ntap1 A=4e-12 P=8e-6
MM7_61 net049 net1 vdd well_2277 sg13_lv_pmos w=1u l=1u m=1
RT2278 vdd well_2278 ntap1 A=4e-12 P=8e-6
MM7_62 net049 net1 vdd well_2278 sg13_lv_pmos w=1u l=1u m=1
RT2279 vdd well_2279 ntap1 A=4e-12 P=8e-6
MM7_63 net049 net1 vdd well_2279 sg13_lv_pmos w=1u l=1u m=1
RT2280 vdd well_2280 ntap1 A=4e-12 P=8e-6
MM7_64 net049 net1 vdd well_2280 sg13_lv_pmos w=1u l=1u m=1
RT2281 vdd well_2281 ntap1 A=4e-12 P=8e-6
MM7_65 net049 net1 vdd well_2281 sg13_lv_pmos w=1u l=1u m=1
RT2282 vdd well_2282 ntap1 A=4e-12 P=8e-6
MM7_66 net049 net1 vdd well_2282 sg13_lv_pmos w=1u l=1u m=1
RT2283 vdd well_2283 ntap1 A=4e-12 P=8e-6
MM7_67 net049 net1 vdd well_2283 sg13_lv_pmos w=1u l=1u m=1
RT2284 vdd well_2284 ntap1 A=4e-12 P=8e-6
MM7_68 net049 net1 vdd well_2284 sg13_lv_pmos w=1u l=1u m=1
RT2285 vdd well_2285 ntap1 A=4e-12 P=8e-6
MM7_69 net049 net1 vdd well_2285 sg13_lv_pmos w=1u l=1u m=1
RT2286 vdd well_2286 ntap1 A=4e-12 P=8e-6
MM7_70 net049 net1 vdd well_2286 sg13_lv_pmos w=1u l=1u m=1
RT2287 net31 well_2287 ntap1 A=4e-12 P=8e-6
MM8_0 dm_2 vinn net31 well_2287 sg13_lv_pmos w=1u l=1u m=1
RT2288 net31 well_2288 ntap1 A=4e-12 P=8e-6
MM8_1 dm_2 vinn net31 well_2288 sg13_lv_pmos w=1u l=1u m=1
RT2289 net31 well_2289 ntap1 A=4e-12 P=8e-6
MM8_2 dm_2 vinn net31 well_2289 sg13_lv_pmos w=1u l=1u m=1
RT2290 net31 well_2290 ntap1 A=4e-12 P=8e-6
MM8_3 dm_2 vinn net31 well_2290 sg13_lv_pmos w=1u l=1u m=1
RT2291 net31 well_2291 ntap1 A=4e-12 P=8e-6
MM8_4 dm_2 vinn net31 well_2291 sg13_lv_pmos w=1u l=1u m=1
RT2292 net31 well_2292 ntap1 A=4e-12 P=8e-6
MM8_5 dm_2 vinn net31 well_2292 sg13_lv_pmos w=1u l=1u m=1
RT2293 net31 well_2293 ntap1 A=4e-12 P=8e-6
MM8_6 dm_2 vinn net31 well_2293 sg13_lv_pmos w=1u l=1u m=1
RT2294 net31 well_2294 ntap1 A=4e-12 P=8e-6
MM8_7 dm_2 vinn net31 well_2294 sg13_lv_pmos w=1u l=1u m=1
RT2295 net31 well_2295 ntap1 A=4e-12 P=8e-6
MM8_8 dm_2 vinn net31 well_2295 sg13_lv_pmos w=1u l=1u m=1
RT2296 net31 well_2296 ntap1 A=4e-12 P=8e-6
MM8_9 dm_2 vinn net31 well_2296 sg13_lv_pmos w=1u l=1u m=1
RT2297 net31 well_2297 ntap1 A=4e-12 P=8e-6
MM8_10 dm_2 vinn net31 well_2297 sg13_lv_pmos w=1u l=1u m=1
RT2298 net31 well_2298 ntap1 A=4e-12 P=8e-6
MM8_11 dm_2 vinn net31 well_2298 sg13_lv_pmos w=1u l=1u m=1
RT2299 net31 well_2299 ntap1 A=4e-12 P=8e-6
MM8_12 dm_2 vinn net31 well_2299 sg13_lv_pmos w=1u l=1u m=1
RT2300 net31 well_2300 ntap1 A=4e-12 P=8e-6
MM8_13 dm_2 vinn net31 well_2300 sg13_lv_pmos w=1u l=1u m=1
RT2301 net31 well_2301 ntap1 A=4e-12 P=8e-6
MM8_14 dm_2 vinn net31 well_2301 sg13_lv_pmos w=1u l=1u m=1
RT2302 net31 well_2302 ntap1 A=4e-12 P=8e-6
MM8_15 dm_2 vinn net31 well_2302 sg13_lv_pmos w=1u l=1u m=1
RT2303 net31 well_2303 ntap1 A=4e-12 P=8e-6
MM8_16 dm_2 vinn net31 well_2303 sg13_lv_pmos w=1u l=1u m=1
RT2304 net31 well_2304 ntap1 A=4e-12 P=8e-6
MM8_17 dm_2 vinn net31 well_2304 sg13_lv_pmos w=1u l=1u m=1
RT2305 net31 well_2305 ntap1 A=4e-12 P=8e-6
MM8_18 dm_2 vinn net31 well_2305 sg13_lv_pmos w=1u l=1u m=1
RT2306 net31 well_2306 ntap1 A=4e-12 P=8e-6
MM8_19 dm_2 vinn net31 well_2306 sg13_lv_pmos w=1u l=1u m=1
RT2307 net31 well_2307 ntap1 A=4e-12 P=8e-6
MM8_20 dm_2 vinn net31 well_2307 sg13_lv_pmos w=1u l=1u m=1
RT2308 net31 well_2308 ntap1 A=4e-12 P=8e-6
MM8_21 dm_2 vinn net31 well_2308 sg13_lv_pmos w=1u l=1u m=1
RT2309 net31 well_2309 ntap1 A=4e-12 P=8e-6
MM8_22 dm_2 vinn net31 well_2309 sg13_lv_pmos w=1u l=1u m=1
RT2310 net31 well_2310 ntap1 A=4e-12 P=8e-6
MM8_23 dm_2 vinn net31 well_2310 sg13_lv_pmos w=1u l=1u m=1
RT2311 net31 well_2311 ntap1 A=4e-12 P=8e-6
MM8_24 dm_2 vinn net31 well_2311 sg13_lv_pmos w=1u l=1u m=1
RT2312 net31 well_2312 ntap1 A=4e-12 P=8e-6
MM8_25 dm_2 vinn net31 well_2312 sg13_lv_pmos w=1u l=1u m=1
RT2313 net31 well_2313 ntap1 A=4e-12 P=8e-6
MM8_26 dm_2 vinn net31 well_2313 sg13_lv_pmos w=1u l=1u m=1
RT2314 net31 well_2314 ntap1 A=4e-12 P=8e-6
MM8_27 dm_2 vinn net31 well_2314 sg13_lv_pmos w=1u l=1u m=1
RT2315 net31 well_2315 ntap1 A=4e-12 P=8e-6
MM8_28 dm_2 vinn net31 well_2315 sg13_lv_pmos w=1u l=1u m=1
RT2316 net31 well_2316 ntap1 A=4e-12 P=8e-6
MM8_29 dm_2 vinn net31 well_2316 sg13_lv_pmos w=1u l=1u m=1
RT2317 net31 well_2317 ntap1 A=4e-12 P=8e-6
MM8_30 dm_2 vinn net31 well_2317 sg13_lv_pmos w=1u l=1u m=1
RT2318 net31 well_2318 ntap1 A=4e-12 P=8e-6
MM8_31 dm_2 vinn net31 well_2318 sg13_lv_pmos w=1u l=1u m=1
RT2319 net31 well_2319 ntap1 A=4e-12 P=8e-6
MM8_32 dm_2 vinn net31 well_2319 sg13_lv_pmos w=1u l=1u m=1
RT2320 net31 well_2320 ntap1 A=4e-12 P=8e-6
MM8_33 dm_2 vinn net31 well_2320 sg13_lv_pmos w=1u l=1u m=1
RT2321 net31 well_2321 ntap1 A=4e-12 P=8e-6
MM8_34 dm_2 vinn net31 well_2321 sg13_lv_pmos w=1u l=1u m=1
RT2322 net31 well_2322 ntap1 A=4e-12 P=8e-6
MM8_35 dm_2 vinn net31 well_2322 sg13_lv_pmos w=1u l=1u m=1
RT2323 net31 well_2323 ntap1 A=4e-12 P=8e-6
MM8_36 dm_2 vinn net31 well_2323 sg13_lv_pmos w=1u l=1u m=1
RT2324 net31 well_2324 ntap1 A=4e-12 P=8e-6
MM8_37 dm_2 vinn net31 well_2324 sg13_lv_pmos w=1u l=1u m=1
RT2325 net31 well_2325 ntap1 A=4e-12 P=8e-6
MM8_38 dm_2 vinn net31 well_2325 sg13_lv_pmos w=1u l=1u m=1
RT2326 net31 well_2326 ntap1 A=4e-12 P=8e-6
MM8_39 dm_2 vinn net31 well_2326 sg13_lv_pmos w=1u l=1u m=1
RT2327 net31 well_2327 ntap1 A=4e-12 P=8e-6
MM8_40 dm_2 vinn net31 well_2327 sg13_lv_pmos w=1u l=1u m=1
RT2328 net31 well_2328 ntap1 A=4e-12 P=8e-6
MM8_41 dm_2 vinn net31 well_2328 sg13_lv_pmos w=1u l=1u m=1
RT2329 net31 well_2329 ntap1 A=4e-12 P=8e-6
MM8_42 dm_2 vinn net31 well_2329 sg13_lv_pmos w=1u l=1u m=1
RT2330 net31 well_2330 ntap1 A=4e-12 P=8e-6
MM8_43 dm_2 vinn net31 well_2330 sg13_lv_pmos w=1u l=1u m=1
RT2331 net31 well_2331 ntap1 A=4e-12 P=8e-6
MM8_44 dm_2 vinn net31 well_2331 sg13_lv_pmos w=1u l=1u m=1
RT2332 net31 well_2332 ntap1 A=4e-12 P=8e-6
MM8_45 dm_2 vinn net31 well_2332 sg13_lv_pmos w=1u l=1u m=1
RT2333 net31 well_2333 ntap1 A=4e-12 P=8e-6
MM8_46 dm_2 vinn net31 well_2333 sg13_lv_pmos w=1u l=1u m=1
RT2334 net31 well_2334 ntap1 A=4e-12 P=8e-6
MM8_47 dm_2 vinn net31 well_2334 sg13_lv_pmos w=1u l=1u m=1
RT2335 net31 well_2335 ntap1 A=4e-12 P=8e-6
MM8_48 dm_2 vinn net31 well_2335 sg13_lv_pmos w=1u l=1u m=1
RT2336 net31 well_2336 ntap1 A=4e-12 P=8e-6
MM8_49 dm_2 vinn net31 well_2336 sg13_lv_pmos w=1u l=1u m=1
RT2337 net31 well_2337 ntap1 A=4e-12 P=8e-6
MM8_50 dm_2 vinn net31 well_2337 sg13_lv_pmos w=1u l=1u m=1
RT2338 net31 well_2338 ntap1 A=4e-12 P=8e-6
MM8_51 dm_2 vinn net31 well_2338 sg13_lv_pmos w=1u l=1u m=1
RT2339 net31 well_2339 ntap1 A=4e-12 P=8e-6
MM8_52 dm_2 vinn net31 well_2339 sg13_lv_pmos w=1u l=1u m=1
RT2340 net31 well_2340 ntap1 A=4e-12 P=8e-6
MM8_53 dm_2 vinn net31 well_2340 sg13_lv_pmos w=1u l=1u m=1
RT2341 net31 well_2341 ntap1 A=4e-12 P=8e-6
MM8_54 dm_2 vinn net31 well_2341 sg13_lv_pmos w=1u l=1u m=1
RT2342 net31 well_2342 ntap1 A=4e-12 P=8e-6
MM8_55 dm_2 vinn net31 well_2342 sg13_lv_pmos w=1u l=1u m=1
RT2343 net31 well_2343 ntap1 A=4e-12 P=8e-6
MM8_56 dm_2 vinn net31 well_2343 sg13_lv_pmos w=1u l=1u m=1
RT2344 net31 well_2344 ntap1 A=4e-12 P=8e-6
MM8_57 dm_2 vinn net31 well_2344 sg13_lv_pmos w=1u l=1u m=1
RT2345 net31 well_2345 ntap1 A=4e-12 P=8e-6
MM8_58 dm_2 vinn net31 well_2345 sg13_lv_pmos w=1u l=1u m=1
RT2346 net31 well_2346 ntap1 A=4e-12 P=8e-6
MM8_59 dm_2 vinn net31 well_2346 sg13_lv_pmos w=1u l=1u m=1
RT2347 net31 well_2347 ntap1 A=4e-12 P=8e-6
MM8_60 dm_2 vinn net31 well_2347 sg13_lv_pmos w=1u l=1u m=1
RT2348 net31 well_2348 ntap1 A=4e-12 P=8e-6
MM8_61 dm_2 vinn net31 well_2348 sg13_lv_pmos w=1u l=1u m=1
RT2349 net31 well_2349 ntap1 A=4e-12 P=8e-6
MM8_62 dm_2 vinn net31 well_2349 sg13_lv_pmos w=1u l=1u m=1
RT2350 net31 well_2350 ntap1 A=4e-12 P=8e-6
MM8_63 dm_2 vinn net31 well_2350 sg13_lv_pmos w=1u l=1u m=1
RT2351 net31 well_2351 ntap1 A=4e-12 P=8e-6
MM8_64 dm_2 vinn net31 well_2351 sg13_lv_pmos w=1u l=1u m=1
RT2352 net31 well_2352 ntap1 A=4e-12 P=8e-6
MM8_65 dm_2 vinn net31 well_2352 sg13_lv_pmos w=1u l=1u m=1
RT2353 net31 well_2353 ntap1 A=4e-12 P=8e-6
MM8_66 dm_2 vinn net31 well_2353 sg13_lv_pmos w=1u l=1u m=1
RT2354 net31 well_2354 ntap1 A=4e-12 P=8e-6
MM8_67 dm_2 vinn net31 well_2354 sg13_lv_pmos w=1u l=1u m=1
RT2355 net31 well_2355 ntap1 A=4e-12 P=8e-6
MM8_68 dm_2 vinn net31 well_2355 sg13_lv_pmos w=1u l=1u m=1
RT2356 net31 well_2356 ntap1 A=4e-12 P=8e-6
MM8_69 dm_2 vinn net31 well_2356 sg13_lv_pmos w=1u l=1u m=1
RT2357 net31 well_2357 ntap1 A=4e-12 P=8e-6
MM8_70 dm_2 vinn net31 well_2357 sg13_lv_pmos w=1u l=1u m=1
RT2358 net31 well_2358 ntap1 A=4e-12 P=8e-6
MM8_71 dm_2 vinn net31 well_2358 sg13_lv_pmos w=1u l=1u m=1
RT2359 net31 well_2359 ntap1 A=4e-12 P=8e-6
MM8_72 dm_2 vinn net31 well_2359 sg13_lv_pmos w=1u l=1u m=1
RT2360 net31 well_2360 ntap1 A=4e-12 P=8e-6
MM8_73 dm_2 vinn net31 well_2360 sg13_lv_pmos w=1u l=1u m=1
RT2361 net31 well_2361 ntap1 A=4e-12 P=8e-6
MM8_74 dm_2 vinn net31 well_2361 sg13_lv_pmos w=1u l=1u m=1
RT2362 net31 well_2362 ntap1 A=4e-12 P=8e-6
MM8_75 dm_2 vinn net31 well_2362 sg13_lv_pmos w=1u l=1u m=1
RT2363 net31 well_2363 ntap1 A=4e-12 P=8e-6
MM8_76 dm_2 vinn net31 well_2363 sg13_lv_pmos w=1u l=1u m=1
RT2364 net31 well_2364 ntap1 A=4e-12 P=8e-6
MM8_77 dm_2 vinn net31 well_2364 sg13_lv_pmos w=1u l=1u m=1
RT2365 net31 well_2365 ntap1 A=4e-12 P=8e-6
MM8_78 dm_2 vinn net31 well_2365 sg13_lv_pmos w=1u l=1u m=1
RT2366 net31 well_2366 ntap1 A=4e-12 P=8e-6
MM8_79 dm_2 vinn net31 well_2366 sg13_lv_pmos w=1u l=1u m=1
RT2367 net31 well_2367 ntap1 A=4e-12 P=8e-6
MM8_80 dm_2 vinn net31 well_2367 sg13_lv_pmos w=1u l=1u m=1
RT2368 net31 well_2368 ntap1 A=4e-12 P=8e-6
MM8_81 dm_2 vinn net31 well_2368 sg13_lv_pmos w=1u l=1u m=1
RT2369 net31 well_2369 ntap1 A=4e-12 P=8e-6
MM8_82 dm_2 vinn net31 well_2369 sg13_lv_pmos w=1u l=1u m=1
RT2370 net31 well_2370 ntap1 A=4e-12 P=8e-6
MM8_83 dm_2 vinn net31 well_2370 sg13_lv_pmos w=1u l=1u m=1
RT2371 net31 well_2371 ntap1 A=4e-12 P=8e-6
MM8_84 dm_2 vinn net31 well_2371 sg13_lv_pmos w=1u l=1u m=1
RT2372 net31 well_2372 ntap1 A=4e-12 P=8e-6
MM8_85 dm_2 vinn net31 well_2372 sg13_lv_pmos w=1u l=1u m=1
RT2373 net31 well_2373 ntap1 A=4e-12 P=8e-6
MM8_86 dm_2 vinn net31 well_2373 sg13_lv_pmos w=1u l=1u m=1
RT2374 net31 well_2374 ntap1 A=4e-12 P=8e-6
MM8_87 dm_2 vinn net31 well_2374 sg13_lv_pmos w=1u l=1u m=1
RT2375 net31 well_2375 ntap1 A=4e-12 P=8e-6
MM8_88 dm_2 vinn net31 well_2375 sg13_lv_pmos w=1u l=1u m=1
RT2376 net31 well_2376 ntap1 A=4e-12 P=8e-6
MM8_89 dm_2 vinn net31 well_2376 sg13_lv_pmos w=1u l=1u m=1
RT2377 net31 well_2377 ntap1 A=4e-12 P=8e-6
MM8_90 dm_2 vinn net31 well_2377 sg13_lv_pmos w=1u l=1u m=1
RT2378 net31 well_2378 ntap1 A=4e-12 P=8e-6
MM8_91 dm_2 vinn net31 well_2378 sg13_lv_pmos w=1u l=1u m=1
RT2379 net31 well_2379 ntap1 A=4e-12 P=8e-6
MM8_92 dm_2 vinn net31 well_2379 sg13_lv_pmos w=1u l=1u m=1
RT2380 net31 well_2380 ntap1 A=4e-12 P=8e-6
MM8_93 dm_2 vinn net31 well_2380 sg13_lv_pmos w=1u l=1u m=1
RT2381 net31 well_2381 ntap1 A=4e-12 P=8e-6
MM8_94 dm_2 vinn net31 well_2381 sg13_lv_pmos w=1u l=1u m=1
RT2382 net31 well_2382 ntap1 A=4e-12 P=8e-6
MM8_95 dm_2 vinn net31 well_2382 sg13_lv_pmos w=1u l=1u m=1
RT2383 net31 well_2383 ntap1 A=4e-12 P=8e-6
MM8_96 dm_2 vinn net31 well_2383 sg13_lv_pmos w=1u l=1u m=1
RT2384 net31 well_2384 ntap1 A=4e-12 P=8e-6
MM8_97 dm_2 vinn net31 well_2384 sg13_lv_pmos w=1u l=1u m=1
RT2385 net31 well_2385 ntap1 A=4e-12 P=8e-6
MM8_98 dm_2 vinn net31 well_2385 sg13_lv_pmos w=1u l=1u m=1
RT2386 net31 well_2386 ntap1 A=4e-12 P=8e-6
MM8_99 dm_2 vinn net31 well_2386 sg13_lv_pmos w=1u l=1u m=1
RT2387 net31 well_2387 ntap1 A=4e-12 P=8e-6
MM8_100 dm_2 vinn net31 well_2387 sg13_lv_pmos w=1u l=1u m=1
RT2388 net31 well_2388 ntap1 A=4e-12 P=8e-6
MM8_101 dm_2 vinn net31 well_2388 sg13_lv_pmos w=1u l=1u m=1
RT2389 net31 well_2389 ntap1 A=4e-12 P=8e-6
MM8_102 dm_2 vinn net31 well_2389 sg13_lv_pmos w=1u l=1u m=1
RT2390 net31 well_2390 ntap1 A=4e-12 P=8e-6
MM8_103 dm_2 vinn net31 well_2390 sg13_lv_pmos w=1u l=1u m=1
RT2391 net31 well_2391 ntap1 A=4e-12 P=8e-6
MM8_104 dm_2 vinn net31 well_2391 sg13_lv_pmos w=1u l=1u m=1
RT2392 net31 well_2392 ntap1 A=4e-12 P=8e-6
MM8_105 dm_2 vinn net31 well_2392 sg13_lv_pmos w=1u l=1u m=1
RT2393 net31 well_2393 ntap1 A=4e-12 P=8e-6
MM8_106 dm_2 vinn net31 well_2393 sg13_lv_pmos w=1u l=1u m=1
RT2394 net31 well_2394 ntap1 A=4e-12 P=8e-6
MM8_107 dm_2 vinn net31 well_2394 sg13_lv_pmos w=1u l=1u m=1
RT2395 net31 well_2395 ntap1 A=4e-12 P=8e-6
MM8_108 dm_2 vinn net31 well_2395 sg13_lv_pmos w=1u l=1u m=1
RT2396 net31 well_2396 ntap1 A=4e-12 P=8e-6
MM8_109 dm_2 vinn net31 well_2396 sg13_lv_pmos w=1u l=1u m=1
RT2397 net31 well_2397 ntap1 A=4e-12 P=8e-6
MM8_110 dm_2 vinn net31 well_2397 sg13_lv_pmos w=1u l=1u m=1
RT2398 net31 well_2398 ntap1 A=4e-12 P=8e-6
MM8_111 dm_2 vinn net31 well_2398 sg13_lv_pmos w=1u l=1u m=1
RT2399 net31 well_2399 ntap1 A=4e-12 P=8e-6
MM8_112 dm_2 vinn net31 well_2399 sg13_lv_pmos w=1u l=1u m=1
RT2400 net31 well_2400 ntap1 A=4e-12 P=8e-6
MM8_113 dm_2 vinn net31 well_2400 sg13_lv_pmos w=1u l=1u m=1
RT2401 net31 well_2401 ntap1 A=4e-12 P=8e-6
MM8_114 dm_2 vinn net31 well_2401 sg13_lv_pmos w=1u l=1u m=1
RT2402 net31 well_2402 ntap1 A=4e-12 P=8e-6
MM8_115 dm_2 vinn net31 well_2402 sg13_lv_pmos w=1u l=1u m=1
RT2403 net31 well_2403 ntap1 A=4e-12 P=8e-6
MM8_116 dm_2 vinn net31 well_2403 sg13_lv_pmos w=1u l=1u m=1
RT2404 net31 well_2404 ntap1 A=4e-12 P=8e-6
MM8_117 dm_2 vinn net31 well_2404 sg13_lv_pmos w=1u l=1u m=1
RT2405 net31 well_2405 ntap1 A=4e-12 P=8e-6
MM8_118 dm_2 vinn net31 well_2405 sg13_lv_pmos w=1u l=1u m=1
RT2406 net31 well_2406 ntap1 A=4e-12 P=8e-6
MM8_119 dm_2 vinn net31 well_2406 sg13_lv_pmos w=1u l=1u m=1
RT2407 net31 well_2407 ntap1 A=4e-12 P=8e-6
MM8_120 dm_2 vinn net31 well_2407 sg13_lv_pmos w=1u l=1u m=1
RT2408 net31 well_2408 ntap1 A=4e-12 P=8e-6
MM8_121 dm_2 vinn net31 well_2408 sg13_lv_pmos w=1u l=1u m=1
RT2409 net31 well_2409 ntap1 A=4e-12 P=8e-6
MM8_122 dm_2 vinn net31 well_2409 sg13_lv_pmos w=1u l=1u m=1
RT2410 net31 well_2410 ntap1 A=4e-12 P=8e-6
MM8_123 dm_2 vinn net31 well_2410 sg13_lv_pmos w=1u l=1u m=1
RT2411 net31 well_2411 ntap1 A=4e-12 P=8e-6
MM8_124 dm_2 vinn net31 well_2411 sg13_lv_pmos w=1u l=1u m=1
RT2412 net31 well_2412 ntap1 A=4e-12 P=8e-6
MM8_125 dm_2 vinn net31 well_2412 sg13_lv_pmos w=1u l=1u m=1
RT2413 net31 well_2413 ntap1 A=4e-12 P=8e-6
MM8_126 dm_2 vinn net31 well_2413 sg13_lv_pmos w=1u l=1u m=1
RT2414 net31 well_2414 ntap1 A=4e-12 P=8e-6
MM8_127 dm_2 vinn net31 well_2414 sg13_lv_pmos w=1u l=1u m=1
RT2415 net31 well_2415 ntap1 A=4e-12 P=8e-6
MM8_128 dm_2 vinn net31 well_2415 sg13_lv_pmos w=1u l=1u m=1
RT2416 net31 well_2416 ntap1 A=4e-12 P=8e-6
MM8_129 dm_2 vinn net31 well_2416 sg13_lv_pmos w=1u l=1u m=1
RT2417 net31 well_2417 ntap1 A=4e-12 P=8e-6
MM8_130 dm_2 vinn net31 well_2417 sg13_lv_pmos w=1u l=1u m=1
RT2418 net31 well_2418 ntap1 A=4e-12 P=8e-6
MM8_131 dm_2 vinn net31 well_2418 sg13_lv_pmos w=1u l=1u m=1
RT2419 net31 well_2419 ntap1 A=4e-12 P=8e-6
MM8_132 dm_2 vinn net31 well_2419 sg13_lv_pmos w=1u l=1u m=1
RT2420 net31 well_2420 ntap1 A=4e-12 P=8e-6
MM8_133 dm_2 vinn net31 well_2420 sg13_lv_pmos w=1u l=1u m=1
RT2421 net31 well_2421 ntap1 A=4e-12 P=8e-6
MM8_134 dm_2 vinn net31 well_2421 sg13_lv_pmos w=1u l=1u m=1
RT2422 net31 well_2422 ntap1 A=4e-12 P=8e-6
MM8_135 dm_2 vinn net31 well_2422 sg13_lv_pmos w=1u l=1u m=1
RT2423 net31 well_2423 ntap1 A=4e-12 P=8e-6
MM8_136 dm_2 vinn net31 well_2423 sg13_lv_pmos w=1u l=1u m=1
RT2424 net31 well_2424 ntap1 A=4e-12 P=8e-6
MM8_137 dm_2 vinn net31 well_2424 sg13_lv_pmos w=1u l=1u m=1
RT2425 net31 well_2425 ntap1 A=4e-12 P=8e-6
MM8_138 dm_2 vinn net31 well_2425 sg13_lv_pmos w=1u l=1u m=1
RT2426 net31 well_2426 ntap1 A=4e-12 P=8e-6
MM8_139 dm_2 vinn net31 well_2426 sg13_lv_pmos w=1u l=1u m=1
RT2427 net31 well_2427 ntap1 A=4e-12 P=8e-6
MM8_140 dm_2 vinn net31 well_2427 sg13_lv_pmos w=1u l=1u m=1
RT2428 net31 well_2428 ntap1 A=4e-12 P=8e-6
MM8_141 dm_2 vinn net31 well_2428 sg13_lv_pmos w=1u l=1u m=1
RT2429 net31 well_2429 ntap1 A=4e-12 P=8e-6
MM8_142 dm_2 vinn net31 well_2429 sg13_lv_pmos w=1u l=1u m=1
RT2430 net31 well_2430 ntap1 A=4e-12 P=8e-6
MM8_143 dm_2 vinn net31 well_2430 sg13_lv_pmos w=1u l=1u m=1
RT2431 net31 well_2431 ntap1 A=4e-12 P=8e-6
MM8_144 dm_2 vinn net31 well_2431 sg13_lv_pmos w=1u l=1u m=1
RT2432 net31 well_2432 ntap1 A=4e-12 P=8e-6
MM8_145 dm_2 vinn net31 well_2432 sg13_lv_pmos w=1u l=1u m=1
RT2433 net31 well_2433 ntap1 A=4e-12 P=8e-6
MM8_146 dm_2 vinn net31 well_2433 sg13_lv_pmos w=1u l=1u m=1
RT2434 net31 well_2434 ntap1 A=4e-12 P=8e-6
MM8_147 dm_2 vinn net31 well_2434 sg13_lv_pmos w=1u l=1u m=1
RT2435 net31 well_2435 ntap1 A=4e-12 P=8e-6
MM9_0 net063 vinp net31 well_2435 sg13_lv_pmos w=1u l=1u m=1
RT2436 net31 well_2436 ntap1 A=4e-12 P=8e-6
MM9_1 net063 vinp net31 well_2436 sg13_lv_pmos w=1u l=1u m=1
RT2437 net31 well_2437 ntap1 A=4e-12 P=8e-6
MM9_2 net063 vinp net31 well_2437 sg13_lv_pmos w=1u l=1u m=1
RT2438 net31 well_2438 ntap1 A=4e-12 P=8e-6
MM9_3 net063 vinp net31 well_2438 sg13_lv_pmos w=1u l=1u m=1
RT2439 net31 well_2439 ntap1 A=4e-12 P=8e-6
MM9_4 net063 vinp net31 well_2439 sg13_lv_pmos w=1u l=1u m=1
RT2440 net31 well_2440 ntap1 A=4e-12 P=8e-6
MM9_5 net063 vinp net31 well_2440 sg13_lv_pmos w=1u l=1u m=1
RT2441 net31 well_2441 ntap1 A=4e-12 P=8e-6
MM9_6 net063 vinp net31 well_2441 sg13_lv_pmos w=1u l=1u m=1
RT2442 net31 well_2442 ntap1 A=4e-12 P=8e-6
MM9_7 net063 vinp net31 well_2442 sg13_lv_pmos w=1u l=1u m=1
RT2443 net31 well_2443 ntap1 A=4e-12 P=8e-6
MM9_8 net063 vinp net31 well_2443 sg13_lv_pmos w=1u l=1u m=1
RT2444 net31 well_2444 ntap1 A=4e-12 P=8e-6
MM9_9 net063 vinp net31 well_2444 sg13_lv_pmos w=1u l=1u m=1
RT2445 net31 well_2445 ntap1 A=4e-12 P=8e-6
MM9_10 net063 vinp net31 well_2445 sg13_lv_pmos w=1u l=1u m=1
RT2446 net31 well_2446 ntap1 A=4e-12 P=8e-6
MM9_11 net063 vinp net31 well_2446 sg13_lv_pmos w=1u l=1u m=1
RT2447 net31 well_2447 ntap1 A=4e-12 P=8e-6
MM9_12 net063 vinp net31 well_2447 sg13_lv_pmos w=1u l=1u m=1
RT2448 net31 well_2448 ntap1 A=4e-12 P=8e-6
MM9_13 net063 vinp net31 well_2448 sg13_lv_pmos w=1u l=1u m=1
RT2449 net31 well_2449 ntap1 A=4e-12 P=8e-6
MM9_14 net063 vinp net31 well_2449 sg13_lv_pmos w=1u l=1u m=1
RT2450 net31 well_2450 ntap1 A=4e-12 P=8e-6
MM9_15 net063 vinp net31 well_2450 sg13_lv_pmos w=1u l=1u m=1
RT2451 net31 well_2451 ntap1 A=4e-12 P=8e-6
MM9_16 net063 vinp net31 well_2451 sg13_lv_pmos w=1u l=1u m=1
RT2452 net31 well_2452 ntap1 A=4e-12 P=8e-6
MM9_17 net063 vinp net31 well_2452 sg13_lv_pmos w=1u l=1u m=1
RT2453 net31 well_2453 ntap1 A=4e-12 P=8e-6
MM9_18 net063 vinp net31 well_2453 sg13_lv_pmos w=1u l=1u m=1
RT2454 net31 well_2454 ntap1 A=4e-12 P=8e-6
MM9_19 net063 vinp net31 well_2454 sg13_lv_pmos w=1u l=1u m=1
RT2455 net31 well_2455 ntap1 A=4e-12 P=8e-6
MM9_20 net063 vinp net31 well_2455 sg13_lv_pmos w=1u l=1u m=1
RT2456 net31 well_2456 ntap1 A=4e-12 P=8e-6
MM9_21 net063 vinp net31 well_2456 sg13_lv_pmos w=1u l=1u m=1
RT2457 net31 well_2457 ntap1 A=4e-12 P=8e-6
MM9_22 net063 vinp net31 well_2457 sg13_lv_pmos w=1u l=1u m=1
RT2458 net31 well_2458 ntap1 A=4e-12 P=8e-6
MM9_23 net063 vinp net31 well_2458 sg13_lv_pmos w=1u l=1u m=1
RT2459 net31 well_2459 ntap1 A=4e-12 P=8e-6
MM9_24 net063 vinp net31 well_2459 sg13_lv_pmos w=1u l=1u m=1
RT2460 net31 well_2460 ntap1 A=4e-12 P=8e-6
MM9_25 net063 vinp net31 well_2460 sg13_lv_pmos w=1u l=1u m=1
RT2461 net31 well_2461 ntap1 A=4e-12 P=8e-6
MM9_26 net063 vinp net31 well_2461 sg13_lv_pmos w=1u l=1u m=1
RT2462 net31 well_2462 ntap1 A=4e-12 P=8e-6
MM9_27 net063 vinp net31 well_2462 sg13_lv_pmos w=1u l=1u m=1
RT2463 net31 well_2463 ntap1 A=4e-12 P=8e-6
MM9_28 net063 vinp net31 well_2463 sg13_lv_pmos w=1u l=1u m=1
RT2464 net31 well_2464 ntap1 A=4e-12 P=8e-6
MM9_29 net063 vinp net31 well_2464 sg13_lv_pmos w=1u l=1u m=1
RT2465 net31 well_2465 ntap1 A=4e-12 P=8e-6
MM9_30 net063 vinp net31 well_2465 sg13_lv_pmos w=1u l=1u m=1
RT2466 net31 well_2466 ntap1 A=4e-12 P=8e-6
MM9_31 net063 vinp net31 well_2466 sg13_lv_pmos w=1u l=1u m=1
RT2467 net31 well_2467 ntap1 A=4e-12 P=8e-6
MM9_32 net063 vinp net31 well_2467 sg13_lv_pmos w=1u l=1u m=1
RT2468 net31 well_2468 ntap1 A=4e-12 P=8e-6
MM9_33 net063 vinp net31 well_2468 sg13_lv_pmos w=1u l=1u m=1
RT2469 net31 well_2469 ntap1 A=4e-12 P=8e-6
MM9_34 net063 vinp net31 well_2469 sg13_lv_pmos w=1u l=1u m=1
RT2470 net31 well_2470 ntap1 A=4e-12 P=8e-6
MM9_35 net063 vinp net31 well_2470 sg13_lv_pmos w=1u l=1u m=1
RT2471 net31 well_2471 ntap1 A=4e-12 P=8e-6
MM9_36 net063 vinp net31 well_2471 sg13_lv_pmos w=1u l=1u m=1
RT2472 net31 well_2472 ntap1 A=4e-12 P=8e-6
MM9_37 net063 vinp net31 well_2472 sg13_lv_pmos w=1u l=1u m=1
RT2473 net31 well_2473 ntap1 A=4e-12 P=8e-6
MM9_38 net063 vinp net31 well_2473 sg13_lv_pmos w=1u l=1u m=1
RT2474 net31 well_2474 ntap1 A=4e-12 P=8e-6
MM9_39 net063 vinp net31 well_2474 sg13_lv_pmos w=1u l=1u m=1
RT2475 net31 well_2475 ntap1 A=4e-12 P=8e-6
MM9_40 net063 vinp net31 well_2475 sg13_lv_pmos w=1u l=1u m=1
RT2476 net31 well_2476 ntap1 A=4e-12 P=8e-6
MM9_41 net063 vinp net31 well_2476 sg13_lv_pmos w=1u l=1u m=1
RT2477 net31 well_2477 ntap1 A=4e-12 P=8e-6
MM9_42 net063 vinp net31 well_2477 sg13_lv_pmos w=1u l=1u m=1
RT2478 net31 well_2478 ntap1 A=4e-12 P=8e-6
MM9_43 net063 vinp net31 well_2478 sg13_lv_pmos w=1u l=1u m=1
RT2479 net31 well_2479 ntap1 A=4e-12 P=8e-6
MM9_44 net063 vinp net31 well_2479 sg13_lv_pmos w=1u l=1u m=1
RT2480 net31 well_2480 ntap1 A=4e-12 P=8e-6
MM9_45 net063 vinp net31 well_2480 sg13_lv_pmos w=1u l=1u m=1
RT2481 net31 well_2481 ntap1 A=4e-12 P=8e-6
MM9_46 net063 vinp net31 well_2481 sg13_lv_pmos w=1u l=1u m=1
RT2482 net31 well_2482 ntap1 A=4e-12 P=8e-6
MM9_47 net063 vinp net31 well_2482 sg13_lv_pmos w=1u l=1u m=1
RT2483 net31 well_2483 ntap1 A=4e-12 P=8e-6
MM9_48 net063 vinp net31 well_2483 sg13_lv_pmos w=1u l=1u m=1
RT2484 net31 well_2484 ntap1 A=4e-12 P=8e-6
MM9_49 net063 vinp net31 well_2484 sg13_lv_pmos w=1u l=1u m=1
RT2485 net31 well_2485 ntap1 A=4e-12 P=8e-6
MM9_50 net063 vinp net31 well_2485 sg13_lv_pmos w=1u l=1u m=1
RT2486 net31 well_2486 ntap1 A=4e-12 P=8e-6
MM9_51 net063 vinp net31 well_2486 sg13_lv_pmos w=1u l=1u m=1
RT2487 net31 well_2487 ntap1 A=4e-12 P=8e-6
MM9_52 net063 vinp net31 well_2487 sg13_lv_pmos w=1u l=1u m=1
RT2488 net31 well_2488 ntap1 A=4e-12 P=8e-6
MM9_53 net063 vinp net31 well_2488 sg13_lv_pmos w=1u l=1u m=1
RT2489 net31 well_2489 ntap1 A=4e-12 P=8e-6
MM9_54 net063 vinp net31 well_2489 sg13_lv_pmos w=1u l=1u m=1
RT2490 net31 well_2490 ntap1 A=4e-12 P=8e-6
MM9_55 net063 vinp net31 well_2490 sg13_lv_pmos w=1u l=1u m=1
RT2491 net31 well_2491 ntap1 A=4e-12 P=8e-6
MM9_56 net063 vinp net31 well_2491 sg13_lv_pmos w=1u l=1u m=1
RT2492 net31 well_2492 ntap1 A=4e-12 P=8e-6
MM9_57 net063 vinp net31 well_2492 sg13_lv_pmos w=1u l=1u m=1
RT2493 net31 well_2493 ntap1 A=4e-12 P=8e-6
MM9_58 net063 vinp net31 well_2493 sg13_lv_pmos w=1u l=1u m=1
RT2494 net31 well_2494 ntap1 A=4e-12 P=8e-6
MM9_59 net063 vinp net31 well_2494 sg13_lv_pmos w=1u l=1u m=1
RT2495 net31 well_2495 ntap1 A=4e-12 P=8e-6
MM9_60 net063 vinp net31 well_2495 sg13_lv_pmos w=1u l=1u m=1
RT2496 net31 well_2496 ntap1 A=4e-12 P=8e-6
MM9_61 net063 vinp net31 well_2496 sg13_lv_pmos w=1u l=1u m=1
RT2497 net31 well_2497 ntap1 A=4e-12 P=8e-6
MM9_62 net063 vinp net31 well_2497 sg13_lv_pmos w=1u l=1u m=1
RT2498 net31 well_2498 ntap1 A=4e-12 P=8e-6
MM9_63 net063 vinp net31 well_2498 sg13_lv_pmos w=1u l=1u m=1
RT2499 net31 well_2499 ntap1 A=4e-12 P=8e-6
MM9_64 net063 vinp net31 well_2499 sg13_lv_pmos w=1u l=1u m=1
RT2500 net31 well_2500 ntap1 A=4e-12 P=8e-6
MM9_65 net063 vinp net31 well_2500 sg13_lv_pmos w=1u l=1u m=1
RT2501 net31 well_2501 ntap1 A=4e-12 P=8e-6
MM9_66 net063 vinp net31 well_2501 sg13_lv_pmos w=1u l=1u m=1
RT2502 net31 well_2502 ntap1 A=4e-12 P=8e-6
MM9_67 net063 vinp net31 well_2502 sg13_lv_pmos w=1u l=1u m=1
RT2503 net31 well_2503 ntap1 A=4e-12 P=8e-6
MM9_68 net063 vinp net31 well_2503 sg13_lv_pmos w=1u l=1u m=1
RT2504 net31 well_2504 ntap1 A=4e-12 P=8e-6
MM9_69 net063 vinp net31 well_2504 sg13_lv_pmos w=1u l=1u m=1
RT2505 net31 well_2505 ntap1 A=4e-12 P=8e-6
MM9_70 net063 vinp net31 well_2505 sg13_lv_pmos w=1u l=1u m=1
RT2506 net31 well_2506 ntap1 A=4e-12 P=8e-6
MM9_71 net063 vinp net31 well_2506 sg13_lv_pmos w=1u l=1u m=1
RT2507 net31 well_2507 ntap1 A=4e-12 P=8e-6
MM9_72 net063 vinp net31 well_2507 sg13_lv_pmos w=1u l=1u m=1
RT2508 net31 well_2508 ntap1 A=4e-12 P=8e-6
MM9_73 net063 vinp net31 well_2508 sg13_lv_pmos w=1u l=1u m=1
RT2509 net31 well_2509 ntap1 A=4e-12 P=8e-6
MM9_74 net063 vinp net31 well_2509 sg13_lv_pmos w=1u l=1u m=1
RT2510 net31 well_2510 ntap1 A=4e-12 P=8e-6
MM9_75 net063 vinp net31 well_2510 sg13_lv_pmos w=1u l=1u m=1
RT2511 net31 well_2511 ntap1 A=4e-12 P=8e-6
MM9_76 net063 vinp net31 well_2511 sg13_lv_pmos w=1u l=1u m=1
RT2512 net31 well_2512 ntap1 A=4e-12 P=8e-6
MM9_77 net063 vinp net31 well_2512 sg13_lv_pmos w=1u l=1u m=1
RT2513 net31 well_2513 ntap1 A=4e-12 P=8e-6
MM9_78 net063 vinp net31 well_2513 sg13_lv_pmos w=1u l=1u m=1
RT2514 net31 well_2514 ntap1 A=4e-12 P=8e-6
MM9_79 net063 vinp net31 well_2514 sg13_lv_pmos w=1u l=1u m=1
RT2515 net31 well_2515 ntap1 A=4e-12 P=8e-6
MM9_80 net063 vinp net31 well_2515 sg13_lv_pmos w=1u l=1u m=1
RT2516 net31 well_2516 ntap1 A=4e-12 P=8e-6
MM9_81 net063 vinp net31 well_2516 sg13_lv_pmos w=1u l=1u m=1
RT2517 net31 well_2517 ntap1 A=4e-12 P=8e-6
MM9_82 net063 vinp net31 well_2517 sg13_lv_pmos w=1u l=1u m=1
RT2518 net31 well_2518 ntap1 A=4e-12 P=8e-6
MM9_83 net063 vinp net31 well_2518 sg13_lv_pmos w=1u l=1u m=1
RT2519 net31 well_2519 ntap1 A=4e-12 P=8e-6
MM9_84 net063 vinp net31 well_2519 sg13_lv_pmos w=1u l=1u m=1
RT2520 net31 well_2520 ntap1 A=4e-12 P=8e-6
MM9_85 net063 vinp net31 well_2520 sg13_lv_pmos w=1u l=1u m=1
RT2521 net31 well_2521 ntap1 A=4e-12 P=8e-6
MM9_86 net063 vinp net31 well_2521 sg13_lv_pmos w=1u l=1u m=1
RT2522 net31 well_2522 ntap1 A=4e-12 P=8e-6
MM9_87 net063 vinp net31 well_2522 sg13_lv_pmos w=1u l=1u m=1
RT2523 net31 well_2523 ntap1 A=4e-12 P=8e-6
MM9_88 net063 vinp net31 well_2523 sg13_lv_pmos w=1u l=1u m=1
RT2524 net31 well_2524 ntap1 A=4e-12 P=8e-6
MM9_89 net063 vinp net31 well_2524 sg13_lv_pmos w=1u l=1u m=1
RT2525 net31 well_2525 ntap1 A=4e-12 P=8e-6
MM9_90 net063 vinp net31 well_2525 sg13_lv_pmos w=1u l=1u m=1
RT2526 net31 well_2526 ntap1 A=4e-12 P=8e-6
MM9_91 net063 vinp net31 well_2526 sg13_lv_pmos w=1u l=1u m=1
RT2527 net31 well_2527 ntap1 A=4e-12 P=8e-6
MM9_92 net063 vinp net31 well_2527 sg13_lv_pmos w=1u l=1u m=1
RT2528 net31 well_2528 ntap1 A=4e-12 P=8e-6
MM9_93 net063 vinp net31 well_2528 sg13_lv_pmos w=1u l=1u m=1
RT2529 net31 well_2529 ntap1 A=4e-12 P=8e-6
MM9_94 net063 vinp net31 well_2529 sg13_lv_pmos w=1u l=1u m=1
RT2530 net31 well_2530 ntap1 A=4e-12 P=8e-6
MM9_95 net063 vinp net31 well_2530 sg13_lv_pmos w=1u l=1u m=1
RT2531 net31 well_2531 ntap1 A=4e-12 P=8e-6
MM9_96 net063 vinp net31 well_2531 sg13_lv_pmos w=1u l=1u m=1
RT2532 net31 well_2532 ntap1 A=4e-12 P=8e-6
MM9_97 net063 vinp net31 well_2532 sg13_lv_pmos w=1u l=1u m=1
RT2533 net31 well_2533 ntap1 A=4e-12 P=8e-6
MM9_98 net063 vinp net31 well_2533 sg13_lv_pmos w=1u l=1u m=1
RT2534 net31 well_2534 ntap1 A=4e-12 P=8e-6
MM9_99 net063 vinp net31 well_2534 sg13_lv_pmos w=1u l=1u m=1
RT2535 net31 well_2535 ntap1 A=4e-12 P=8e-6
MM9_100 net063 vinp net31 well_2535 sg13_lv_pmos w=1u l=1u m=1
RT2536 net31 well_2536 ntap1 A=4e-12 P=8e-6
MM9_101 net063 vinp net31 well_2536 sg13_lv_pmos w=1u l=1u m=1
RT2537 net31 well_2537 ntap1 A=4e-12 P=8e-6
MM9_102 net063 vinp net31 well_2537 sg13_lv_pmos w=1u l=1u m=1
RT2538 net31 well_2538 ntap1 A=4e-12 P=8e-6
MM9_103 net063 vinp net31 well_2538 sg13_lv_pmos w=1u l=1u m=1
RT2539 net31 well_2539 ntap1 A=4e-12 P=8e-6
MM9_104 net063 vinp net31 well_2539 sg13_lv_pmos w=1u l=1u m=1
RT2540 net31 well_2540 ntap1 A=4e-12 P=8e-6
MM9_105 net063 vinp net31 well_2540 sg13_lv_pmos w=1u l=1u m=1
RT2541 net31 well_2541 ntap1 A=4e-12 P=8e-6
MM9_106 net063 vinp net31 well_2541 sg13_lv_pmos w=1u l=1u m=1
RT2542 net31 well_2542 ntap1 A=4e-12 P=8e-6
MM9_107 net063 vinp net31 well_2542 sg13_lv_pmos w=1u l=1u m=1
RT2543 net31 well_2543 ntap1 A=4e-12 P=8e-6
MM9_108 net063 vinp net31 well_2543 sg13_lv_pmos w=1u l=1u m=1
RT2544 net31 well_2544 ntap1 A=4e-12 P=8e-6
MM9_109 net063 vinp net31 well_2544 sg13_lv_pmos w=1u l=1u m=1
RT2545 net31 well_2545 ntap1 A=4e-12 P=8e-6
MM9_110 net063 vinp net31 well_2545 sg13_lv_pmos w=1u l=1u m=1
RT2546 net31 well_2546 ntap1 A=4e-12 P=8e-6
MM9_111 net063 vinp net31 well_2546 sg13_lv_pmos w=1u l=1u m=1
RT2547 net31 well_2547 ntap1 A=4e-12 P=8e-6
MM9_112 net063 vinp net31 well_2547 sg13_lv_pmos w=1u l=1u m=1
RT2548 net31 well_2548 ntap1 A=4e-12 P=8e-6
MM9_113 net063 vinp net31 well_2548 sg13_lv_pmos w=1u l=1u m=1
RT2549 net31 well_2549 ntap1 A=4e-12 P=8e-6
MM9_114 net063 vinp net31 well_2549 sg13_lv_pmos w=1u l=1u m=1
RT2550 net31 well_2550 ntap1 A=4e-12 P=8e-6
MM9_115 net063 vinp net31 well_2550 sg13_lv_pmos w=1u l=1u m=1
RT2551 net31 well_2551 ntap1 A=4e-12 P=8e-6
MM9_116 net063 vinp net31 well_2551 sg13_lv_pmos w=1u l=1u m=1
RT2552 net31 well_2552 ntap1 A=4e-12 P=8e-6
MM9_117 net063 vinp net31 well_2552 sg13_lv_pmos w=1u l=1u m=1
RT2553 net31 well_2553 ntap1 A=4e-12 P=8e-6
MM9_118 net063 vinp net31 well_2553 sg13_lv_pmos w=1u l=1u m=1
RT2554 net31 well_2554 ntap1 A=4e-12 P=8e-6
MM9_119 net063 vinp net31 well_2554 sg13_lv_pmos w=1u l=1u m=1
RT2555 net31 well_2555 ntap1 A=4e-12 P=8e-6
MM9_120 net063 vinp net31 well_2555 sg13_lv_pmos w=1u l=1u m=1
RT2556 net31 well_2556 ntap1 A=4e-12 P=8e-6
MM9_121 net063 vinp net31 well_2556 sg13_lv_pmos w=1u l=1u m=1
RT2557 net31 well_2557 ntap1 A=4e-12 P=8e-6
MM9_122 net063 vinp net31 well_2557 sg13_lv_pmos w=1u l=1u m=1
RT2558 net31 well_2558 ntap1 A=4e-12 P=8e-6
MM9_123 net063 vinp net31 well_2558 sg13_lv_pmos w=1u l=1u m=1
RT2559 net31 well_2559 ntap1 A=4e-12 P=8e-6
MM9_124 net063 vinp net31 well_2559 sg13_lv_pmos w=1u l=1u m=1
RT2560 net31 well_2560 ntap1 A=4e-12 P=8e-6
MM9_125 net063 vinp net31 well_2560 sg13_lv_pmos w=1u l=1u m=1
RT2561 net31 well_2561 ntap1 A=4e-12 P=8e-6
MM9_126 net063 vinp net31 well_2561 sg13_lv_pmos w=1u l=1u m=1
RT2562 net31 well_2562 ntap1 A=4e-12 P=8e-6
MM9_127 net063 vinp net31 well_2562 sg13_lv_pmos w=1u l=1u m=1
RT2563 net31 well_2563 ntap1 A=4e-12 P=8e-6
MM9_128 net063 vinp net31 well_2563 sg13_lv_pmos w=1u l=1u m=1
RT2564 net31 well_2564 ntap1 A=4e-12 P=8e-6
MM9_129 net063 vinp net31 well_2564 sg13_lv_pmos w=1u l=1u m=1
RT2565 net31 well_2565 ntap1 A=4e-12 P=8e-6
MM9_130 net063 vinp net31 well_2565 sg13_lv_pmos w=1u l=1u m=1
RT2566 net31 well_2566 ntap1 A=4e-12 P=8e-6
MM9_131 net063 vinp net31 well_2566 sg13_lv_pmos w=1u l=1u m=1
RT2567 net31 well_2567 ntap1 A=4e-12 P=8e-6
MM9_132 net063 vinp net31 well_2567 sg13_lv_pmos w=1u l=1u m=1
RT2568 net31 well_2568 ntap1 A=4e-12 P=8e-6
MM9_133 net063 vinp net31 well_2568 sg13_lv_pmos w=1u l=1u m=1
RT2569 net31 well_2569 ntap1 A=4e-12 P=8e-6
MM9_134 net063 vinp net31 well_2569 sg13_lv_pmos w=1u l=1u m=1
RT2570 net31 well_2570 ntap1 A=4e-12 P=8e-6
MM9_135 net063 vinp net31 well_2570 sg13_lv_pmos w=1u l=1u m=1
RT2571 net31 well_2571 ntap1 A=4e-12 P=8e-6
MM9_136 net063 vinp net31 well_2571 sg13_lv_pmos w=1u l=1u m=1
RT2572 net31 well_2572 ntap1 A=4e-12 P=8e-6
MM9_137 net063 vinp net31 well_2572 sg13_lv_pmos w=1u l=1u m=1
RT2573 net31 well_2573 ntap1 A=4e-12 P=8e-6
MM9_138 net063 vinp net31 well_2573 sg13_lv_pmos w=1u l=1u m=1
RT2574 net31 well_2574 ntap1 A=4e-12 P=8e-6
MM9_139 net063 vinp net31 well_2574 sg13_lv_pmos w=1u l=1u m=1
RT2575 net31 well_2575 ntap1 A=4e-12 P=8e-6
MM9_140 net063 vinp net31 well_2575 sg13_lv_pmos w=1u l=1u m=1
RT2576 net31 well_2576 ntap1 A=4e-12 P=8e-6
MM9_141 net063 vinp net31 well_2576 sg13_lv_pmos w=1u l=1u m=1
RT2577 net31 well_2577 ntap1 A=4e-12 P=8e-6
MM9_142 net063 vinp net31 well_2577 sg13_lv_pmos w=1u l=1u m=1
RT2578 net31 well_2578 ntap1 A=4e-12 P=8e-6
MM9_143 net063 vinp net31 well_2578 sg13_lv_pmos w=1u l=1u m=1
RT2579 net31 well_2579 ntap1 A=4e-12 P=8e-6
MM9_144 net063 vinp net31 well_2579 sg13_lv_pmos w=1u l=1u m=1
RT2580 net31 well_2580 ntap1 A=4e-12 P=8e-6
MM9_145 net063 vinp net31 well_2580 sg13_lv_pmos w=1u l=1u m=1
RT2581 net31 well_2581 ntap1 A=4e-12 P=8e-6
MM9_146 net063 vinp net31 well_2581 sg13_lv_pmos w=1u l=1u m=1
RT2582 net31 well_2582 ntap1 A=4e-12 P=8e-6
MM9_147 net063 vinp net31 well_2582 sg13_lv_pmos w=1u l=1u m=1
RTSUB vss sub ptap1 A=4e-12 P=8e-6
C0_0 net050 vout cap_cmim w=51.18u l=51.18u m=1
C0_1 net050 vout cap_cmim w=51.18u l=51.18u m=1
C0_2 net050 vout cap_cmim w=51.18u l=51.18u m=1
C0_3 net050 vout cap_cmim w=51.18u l=51.18u m=1
C0_4 net050 vout cap_cmim w=51.18u l=51.18u m=1
C0_5 net050 vout cap_cmim w=51.18u l=51.18u m=1
C0_6 net050 vout cap_cmim w=51.18u l=51.18u m=1
C0_7 net050 vout cap_cmim w=51.18u l=51.18u m=1
C0_8 net050 vout cap_cmim w=51.18u l=51.18u m=1
C0_9 net050 vout cap_cmim w=51.18u l=51.18u m=1
C0_10 net050 vout cap_cmim w=51.18u l=51.18u m=1
C0_11 net050 vout cap_cmim w=51.18u l=51.18u m=1
C0_12 net050 vout cap_cmim w=51.18u l=51.18u m=1
C0_13 net050 vout cap_cmim w=51.18u l=51.18u m=1
C0_14 net050 vout cap_cmim w=51.18u l=51.18u m=1
C0_15 net050 vout cap_cmim w=51.18u l=51.18u m=1
C1_0 net050 net049 cap_cmim w=48.74u l=48.74u m=1
C1_1 net050 net049 cap_cmim w=48.74u l=48.74u m=1
C1_2 net050 net049 cap_cmim w=48.74u l=48.74u m=1
C1_3 net050 net049 cap_cmim w=48.74u l=48.74u m=1
C1_4 net050 net049 cap_cmim w=48.74u l=48.74u m=1
C1_5 net050 net049 cap_cmim w=48.74u l=48.74u m=1
C1_6 net050 net049 cap_cmim w=48.74u l=48.74u m=1
.ends amp_014_ramos_pfc
