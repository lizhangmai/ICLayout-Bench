* Copyright 2026 Danial Noori Zadeh. See collection LICENSE and NOTICE.
* Fixed IHP binding; external bias ports and native physical taps.
.subckt amp_026_fan_chopper_ota vinp vinn voutp voutn vdd vss vb1 vb2 vb3 vb4
XT0 vdd well_0 ntap1 A=4e-12 P=8e-6
XM1 tail vb4 vdd well_0 sg13_lv_pmos w=20u l=1u m=1
XT1 vdd well_1 ntap1 A=4e-12 P=8e-6
XM10 out1_n vb3 casc_src_n well_1 sg13_lv_pmos w=10u l=0.3u m=1
XT2 vdd well_2 ntap1 A=4e-12 P=8e-6
XM11 out1_p vb3 casc_src_p well_2 sg13_lv_pmos w=10u l=0.3u m=1
XT3 vss sub ptap1 A=4e-12 P=8e-6
XM12 out1_p vb2 fold_p sub sg13_lv_nmos w=5u l=0.3u m=1
XT4 vss sub ptap1 A=4e-12 P=8e-6
XM13 out1_n vb2 fold_n sub sg13_lv_nmos w=5u l=0.3u m=1
XT5 vss sub ptap1 A=4e-12 P=8e-6
XM14 voutp g2_p vss sub sg13_lv_nmos w=20u l=0.25u m=1
XT6 vss sub ptap1 A=4e-12 P=8e-6
XM15 voutn g2_n vss sub sg13_lv_nmos w=20u l=0.25u m=1
XT7 vss sub ptap1 A=4e-12 P=8e-6
XM16 out1_n vdd g2_n sub sg13_lv_nmos w=2u l=0.13u m=1
XT8 vdd well_8 ntap1 A=4e-12 P=8e-6
XM17 g2_n vss out1_n well_8 sg13_lv_pmos w=2u l=0.13u m=1
XT9 vss sub ptap1 A=4e-12 P=8e-6
XM18 out1_p vdd g2_p sub sg13_lv_nmos w=2u l=0.13u m=1
XT10 vdd well_10 ntap1 A=4e-12 P=8e-6
XM19 g2_p vss out1_p well_10 sg13_lv_pmos w=2u l=0.13u m=1
XT11 vdd well_11 ntap1 A=4e-12 P=8e-6
XM2 fold_p vinp tail well_11 sg13_lv_pmos w=20u l=0.5u m=1
XT12 vss sub ptap1 A=4e-12 P=8e-6
XM20 out1_p vss g2_n sub sg13_lv_nmos w=2u l=0.13u m=1
XT13 vdd well_13 ntap1 A=4e-12 P=8e-6
XM21 g2_n vdd out1_p well_13 sg13_lv_pmos w=2u l=0.13u m=1
XT14 vss sub ptap1 A=4e-12 P=8e-6
XM22 out1_n vss g2_p sub sg13_lv_nmos w=2u l=0.13u m=1
XT15 vdd well_15 ntap1 A=4e-12 P=8e-6
XM23 g2_p vdd out1_n well_15 sg13_lv_pmos w=2u l=0.13u m=1
XT16 vdd well_16 ntap1 A=4e-12 P=8e-6
XM3 fold_n vinn tail well_16 sg13_lv_pmos w=20u l=0.5u m=1
XT17 vss sub ptap1 A=4e-12 P=8e-6
XM4 fold_p vb1 vss sub sg13_lv_nmos w=10u l=1u m=1
XT18 vss sub ptap1 A=4e-12 P=8e-6
XM5 fold_n vb1 vss sub sg13_lv_nmos w=10u l=1u m=1
XT19 vdd well_19 ntap1 A=4e-12 P=8e-6
XM6 casc_src_n vb4 vdd well_19 sg13_lv_pmos w=10u l=1u m=1
XT20 vdd well_20 ntap1 A=4e-12 P=8e-6
XM7 casc_src_p vb4 vdd well_20 sg13_lv_pmos w=10u l=1u m=1
XT21 vdd well_21 ntap1 A=4e-12 P=8e-6
XM8 voutp vb4 vdd well_21 sg13_lv_pmos w=20u l=1u m=1
XT22 vdd well_22 ntap1 A=4e-12 P=8e-6
XM9 voutn vb4 vdd well_22 sg13_lv_pmos w=20u l=1u m=1
XTSUB vss sub ptap1 A=4e-12 P=8e-6
XCM1_0 g2_p voutp cap_cmim w=44.67u l=44.67u m=1
XCM1_1 g2_p voutp cap_cmim w=44.67u l=44.67u m=1
XCM2_0 g2_n voutn cap_cmim w=44.67u l=44.67u m=1
XCM2_1 g2_n voutn cap_cmim w=44.67u l=44.67u m=1
.ends amp_026_fan_chopper_ota
