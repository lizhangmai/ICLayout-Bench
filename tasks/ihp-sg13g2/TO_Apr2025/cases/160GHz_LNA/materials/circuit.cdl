* SPDX-License-Identifier: Apache-2.0
* Maintained Layout-Bench derivative: four direct-coupled common-emitter
* npn13G2 stages with explicit interstage RBIAS clamps and substrate tap.
* The le/we values describe the drawn PCell geometry used by strict LVS.
.subckt LNA160_FOUR_STAGE IN OUT VDD VSS VBIAS
QQ1 N1 IN E1 SUBSTRATE npn13G2 le=900e-9 we=70e-9 Nx=1
QQ2 N2 N1 E2 SUBSTRATE npn13G2 le=900e-9 we=70e-9 Nx=1
QQ3 N3 N2 E3 SUBSTRATE npn13G2 le=900e-9 we=70e-9 Nx=1
QQ4 OUT N3 E4 SUBSTRATE npn13G2 le=900e-9 we=70e-9 Nx=1
RCL1 VDD N1 SUBSTRATE rppd w=2u l=20u ps=0u b=0 m=1
RCL2 VDD N2 SUBSTRATE rppd w=2u l=20u ps=0u b=0 m=1
RCL3 VDD N3 SUBSTRATE rppd w=2u l=20u ps=0u b=0 m=1
RCL4 VDD OUT SUBSTRATE rppd w=2u l=20u ps=0u b=0 m=1
REL1 E1 VSS SUBSTRATE rsil w=4u l=20.00u b=0 m=1
REL2 E2 VSS SUBSTRATE rsil w=4u l=20.01u b=0 m=1
REL3 E3 VSS SUBSTRATE rsil w=4u l=20.02u b=0 m=1
REL4 E4 VSS SUBSTRATE rsil w=4u l=20.03u b=0 m=1
RBIAS2 N1 VBIAS SUBSTRATE rppd w=1u l=4u ps=0u b=0 m=1
RBIAS3 N2 VBIAS SUBSTRATE rppd w=1u l=4u ps=0u b=0 m=1
RBIAS4 N3 VBIAS SUBSTRATE rppd w=1u l=4u ps=0u b=0 m=1
* The finite tap is part of the maintained circuit and is physically present
* in the reference GDS.  A/P are the layout geometry annotations.
RSUB VSS SUBSTRATE ptap1 A=4e-12 P=8e-6
.ends LNA160_FOUR_STAGE
