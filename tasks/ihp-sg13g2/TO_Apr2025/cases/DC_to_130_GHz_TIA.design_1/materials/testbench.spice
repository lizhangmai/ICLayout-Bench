* SPDX-License-Identifier: Apache-2.0
* Nominal AC/DC functional check of the Layout-Bench two-stage TIA derivative.
* Two independent 2 V supplies, 26.85 C, nominal upstream model corners.
* External RF ports are DC-blocked in the source; no DC input/output load.
* Current input, 50 fF output load; the qualified band ends at 100 MHz.
* The original 130 GHz RF/EM claim is outside this test boundary.
.lib /workspace/support/models/cornerHBT.lib hbt_typ
.lib /workspace/support/models/cornerRES.lib res_typ
.lib /workspace/support/models/cornerCAP.lib cap_typ
.include circuit.spice
.param input_current=0
.include parameters.spice
* Anchor DC-floating capacitive islands while retaining their AC coupling.
.options rshunt=1e12 reltol=1e-6 vntol=1e-8 abstol=1e-12
.temp 26.85
VCC1 vcc1 0 2
VCC2 vcc2 0 2
IIN 0 injected DC {input_current} AC 1
VSENSE injected input 0
CLOAD output 0 50f
XDUT input output vcc1 vcc2 0 FMD_QNC_03a_TIA_1
.control
set numdgt=12
op
let input_bias = v(input)
let output_bias = v(output)
let supply1_current = -i(VCC1)
let supply2_current = -i(VCC2)
let supply_power = -v(vcc1)*i(VCC1)-v(vcc2)*i(VCC2)
print input_bias output_bias supply1_current supply2_current supply_power
write operating_point.raw all
ac dec 40 1meg 100meg
let signed_transimpedance = real(v(output)/i(VSENSE))
let magnitude_transimpedance = mag(v(output)/i(VSENSE))
meas ac transimpedance_low find signed_transimpedance at=1meg
meas ac transimpedance_high find magnitude_transimpedance at=100meg
write frequency_response.raw all
quit
.endc
.end
