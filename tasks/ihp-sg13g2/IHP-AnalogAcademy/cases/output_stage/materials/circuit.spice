* Maintained Layout-Bench derivative from the qualified full_OTA output core.
* X instances call the reviewed SG13G2 ngspice wrapper subcircuits.
.subckt output_stage vdd iout vout vss dn4
XM5 vout iout vdd bulk4 sg13_lv_pmos w=75u l=2.08u ng=8 m=1 mm_ok=1
XM6 vout dn4 vss bulk2 sg13_lv_nmos w=28.8u l=9.75u ng=4 m=1 mm_ok=1
XM9 iout iout vdd bulk4 sg13_lv_pmos w=75u l=2.08u ng=8 m=1 mm_ok=1
XC2 dn4 vout cap_cmim w=22.295e-6 l=22.295e-6 m=1 mm_ok=1
* Keep the tap resistance explicit in the simulator dialect.  ngspice's
* ptap1/ntap1 models do not derive R from the CDL A/P annotations.
XR4 vss bulk2 ptap1 A=30.288e-12 P=201.92e-6 R=4.220354
XR5 vdd bulk4 ntap1 A=26.815e-12 P=173e-6 R=4.904537
.ends output_stage
