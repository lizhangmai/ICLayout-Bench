* Maintained Layout-Bench derivative extracted from the qualified full_OTA block.
* This standalone output stage is deliberately self-consistent with the
* maintained witness layout; the archived upstream CDL is diagnostic provenance.
.subckt output_stage vdd iout vout vss dn4
*.PININFO vdd:B iout:B vout:B vss:B dn4:B
MM5 vout iout vdd bulk4 sg13_lv_pmos w=75u l=2.08u ng=8 m=1
MM6 vout dn4 vss bulk2 sg13_lv_nmos w=28.8u l=9.75u ng=4 m=1
MM9 iout iout vdd bulk4 sg13_lv_pmos w=75u l=2.08u ng=8 m=1
CC2 dn4 vout cap_cmim w=22.295e-6 l=22.295e-6 m=1
RR4 vss bulk2 ptap1 A=30.288e-12 P=201.92e-6
RR5 vdd bulk4 ntap1 A=26.815e-12 P=173e-6
.ends output_stage
