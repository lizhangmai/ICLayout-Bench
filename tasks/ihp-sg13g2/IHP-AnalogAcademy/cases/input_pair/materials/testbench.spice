* Input-pair differential gm test at the pinned typical model corner.
* The deck is used unchanged for source and extracted-netlist simulations.
* DUT port order: v- v+ vdd dn3 dn4 tail.
.lib /workspace/support/models/cornerMOSlv.lib mos_tt
.lib /workspace/support/models/cornerRES.lib res_typ
.include dut.spice
.include parameters.spice
.temp 27
* Numerical conditioning for extracted floating nodes only.
.option rshunt=1e12
VDD vdd 0 DC 1.2
ITAIL vdd tail DC {tail_current}
VM vm 0 DC {common_mode} AC -0.5
VP vp 0 DC {common_mode} AC 0.5
RD3 dn3 0 {drain_load}
RD4 dn4 0 {drain_load}
XDUT vm vp vdd dn3 dn4 tail input_common_centroid
.control
set noaskquit
set numdgt=12
op
let tail_voltage = v(tail)
let drain_balance = v(dn3)-v(dn4)
let common_drain = (v(dn3)+v(dn4))/2
let supply_power = -v(vdd)*i(VDD)
print tail_voltage drain_balance common_drain supply_power
write input-op.raw all
ac dec 40 1 1g
let differential_gain = (v(dn3)-v(dn4))/(v(vp)-v(vm))
let differential_gain_abs = abs(differential_gain)
meas ac differential_gain find differential_gain_abs at=1meg
meas ac differential_gain_high find differential_gain_abs at=100meg
write input-ac.raw all
quit
.endc
.end
