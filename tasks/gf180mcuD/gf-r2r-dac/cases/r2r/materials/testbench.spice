* GF180MCU nominal characterization: 3.3 V, 27 C, typical models.
.include "support/models.spice"
.include "dut.spice"
.include "parameters.spice"
.temp 27
VDD unused 0 3.3
CLOAD out 0 1p
XDUT b7 b1 b0 b2 b3 b4 b5 b6 out 0 r2r
V0 b0 0 PWL(0 0 10n 0 10.1n {3.3*bit0})
V1 b1 0 PWL(0 0 10n 0 10.1n {3.3*bit1})
V2 b2 0 PWL(0 0 10n 0 10.1n {3.3*bit2})
V3 b3 0 PWL(0 0 10n 0 10.1n {3.3*bit3})
V4 b4 0 PWL(0 0 10n 0 10.1n {3.3*bit4})
V5 b5 0 PWL(0 0 10n 0 10.1n {3.3*bit5})
V6 b6 0 PWL(0 0 10n 0 10.1n {3.3*bit6})
V7 b7 0 PWL(0 0 10n 0 10.1n {3.3*bit7})
.control
tran 1n 2u
meas tran output_v find v(out) at=1.9u
meas tran early_v find v(out) at=1u
let expected=3.3*(v(b0)/3.3+2*v(b1)/3.3+4*v(b2)/3.3+8*v(b3)/3.3+16*v(b4)/3.3+32*v(b5)/3.3+64*v(b6)/3.3+128*v(b7)/3.3)/256
let error_v=abs(output_v-expected[length(expected)-1])
let settling_error_v=abs(early_v-expected[length(expected)-1])
print error_v settling_error_v
write waveform.raw
quit
.endc
.end
