* Derived from pinned analog-db; Copyright 2026 Danial Noori Zadeh.
* See collection license; 5 nm geometry, physical R/C, explicit interface.
.subckt ldo_005_buffered_ref vdd vout vss vref
C1_0 vout vss cap_mim_2f0fF w=20u l=19.23u
C1_1 vout vss cap_mim_2f0fF w=20u l=19.23u
C1_2 vout vss cap_mim_2f0fF w=20u l=19.23u
C1_3 vout vss cap_mim_2f0fF w=20u l=19.23u
C1_4 vout vss cap_mim_2f0fF w=20u l=19.23u
C1_5 vout vss cap_mim_2f0fF w=20u l=19.23u
C1_6 vout vss cap_mim_2f0fF w=20u l=19.23u
C1_7 vout vss cap_mim_2f0fF w=20u l=19.23u
C1_8 vout vss cap_mim_2f0fF w=20u l=19.23u
C1_9 vout vss cap_mim_2f0fF w=20u l=19.23u
C1_10 vout vss cap_mim_2f0fF w=20u l=19.23u
C1_11 vout vss cap_mim_2f0fF w=20u l=19.23u
C1_12 vout vss cap_mim_2f0fF w=20u l=19.23u
CEAC_0 ea_ncz ea_out cap_mim_2f0fF w=10u l=10u
CRAC_0 ra_ncz v_ref_out cap_mim_2f0fF w=20u l=18.785u
CRAC_1 ra_ncz v_ref_out cap_mim_2f0fF w=20u l=18.785u
CRAC_2 ra_ncz v_ref_out cap_mim_2f0fF w=20u l=18.785u
CRAC_3 ra_ncz v_ref_out cap_mim_2f0fF w=20u l=18.785u
CRAC_4 ra_ncz v_ref_out cap_mim_2f0fF w=20u l=18.785u
CRAC_5 ra_ncz v_ref_out cap_mim_2f0fF w=20u l=18.785u
C_LPF_0 v_lpf_out vss cap_mim_2f0fF w=20u l=19.23u
C_LPF_1 v_lpf_out vss cap_mim_2f0fF w=20u l=19.23u
C_LPF_2 v_lpf_out vss cap_mim_2f0fF w=20u l=19.23u
C_LPF_3 v_lpf_out vss cap_mim_2f0fF w=20u l=19.23u
C_LPF_4 v_lpf_out vss cap_mim_2f0fF w=20u l=19.23u
C_LPF_5 v_lpf_out vss cap_mim_2f0fF w=20u l=19.23u
C_LPF_6 v_lpf_out vss cap_mim_2f0fF w=20u l=19.23u
C_LPF_7 v_lpf_out vss cap_mim_2f0fF w=20u l=19.23u
C_LPF_8 v_lpf_out vss cap_mim_2f0fF w=20u l=19.23u
C_LPF_9 v_lpf_out vss cap_mim_2f0fF w=20u l=19.23u
C_LPF_10 v_lpf_out vss cap_mim_2f0fF w=20u l=19.23u
C_LPF_11 v_lpf_out vss cap_mim_2f0fF w=20u l=19.23u
C_LPF_12 v_lpf_out vss cap_mim_2f0fF w=20u l=19.23u
R1_0 v_ref_out R1_seg1 vss ppolyf_u_1k w=1u l=50u
R1_1 R1_seg1 v_ref_fb vss ppolyf_u_1k w=1u l=50u
R2_0 v_ref_fb R2_seg1 vss ppolyf_u_1k w=1u l=50u
R2_1 R2_seg1 vss vss ppolyf_u_1k w=1u l=50u
R3_0 vout vss vss ppolyf_u_1k w=1u l=10u
REAND_0 ea_na ea_nd vss ppolyf_u_1k w=1u l=50u
REAZ_0 ea_nb ea_ncz vss ppolyf_u_1k w=1u l=28.43u
RRAZ_0 ra_nb ra_ncz vss ppolyf_u_1k w=1u l=30.855u
R_LPF_0 v_ref_out v_lpf_out vss ppolyf_u_1k w=1u l=10u
MMEA_1_0 ea_na v_lpf_out ea_tail vss nfet_06v0 w=68.54u l=0.7u
MMEA_2_0 ea_nb vout ea_tail vss nfet_06v0 w=68.54u l=0.7u
MMEA_3_0 ea_na ea_nd vdd vdd pfet_06v0 w=100u l=0.55u
MMEA_4_0 ea_nlev ea_na ea_nd vdd pfet_06v0 w=10u l=0.55u
MMEA_5_0 ea_nb ea_nd vdd vdd pfet_06v0 w=100u l=0.55u
MMEA_6_0 ea_out ea_nb vdd vdd pfet_06v0 w=14u l=3.835u
MMEA_B0_0 ea_ibias ea_ibias vss vss nfet_06v0 w=34.535u l=2u
MMEA_BC_0 ea_tail ea_ibias vss vss nfet_06v0 w=34.535u l=2u
MMEA_BF_0 ea_nlev ea_ibias vss vss nfet_06v0 w=5u l=2u
MMEA_BO_0 ea_out ea_ibias vss vss nfet_06v0 w=34.535u l=2u
MMEA_BP_0 ea_ibias ea_ibias vdd vdd pfet_06v0 w=6.31u l=2u
MMP_0 vout ea_out vdd vdd pfet_06v0 w=20u l=0.6u
MMP_1 vout ea_out vdd vdd pfet_06v0 w=20u l=0.6u
MMP_2 vout ea_out vdd vdd pfet_06v0 w=20u l=0.6u
MMP_3 vout ea_out vdd vdd pfet_06v0 w=20u l=0.6u
MMP_4 vout ea_out vdd vdd pfet_06v0 w=20u l=0.6u
MMP_5 vout ea_out vdd vdd pfet_06v0 w=20u l=0.6u
MMP_6 vout ea_out vdd vdd pfet_06v0 w=20u l=0.6u
MMRA_1_0 ra_na v_ref_fb ra_tail vss nfet_06v0 w=86.42u l=0.7u
MMRA_2_0 ra_nb vref ra_tail vss nfet_06v0 w=86.42u l=0.7u
MMRA_3_0 ra_na ra_na vdd vdd pfet_06v0 w=20u l=1u
MMRA_4_0 ra_nb ra_na vdd vdd pfet_06v0 w=20u l=1u
MMRA_5_0 v_ref_out ra_nb vdd vdd pfet_06v0 w=37.76u l=2.645u
MMRA_B0_0 ra_ibias ra_ibias vss vss nfet_06v0 w=12u l=2u
MMRA_BC_0 ra_tail ra_ibias vss vss nfet_06v0 w=8.315u l=2u
MMRA_BO_0 v_ref_out ra_ibias vss vss nfet_06v0 w=4u l=2u
MMRA_BP_0 ra_ibias ra_ibias vdd vdd pfet_06v0 w=10.845u l=2u
.ends ldo_005_buffered_ref
