* Maintained Layout-Bench testbench. SPDX-License-Identifier: MIT
* GF180 externally biased LDO nominal DC and AC measurements.
.include support/models.spice
.include dut.spice
.include parameters.spice
.temp 27
VDD vdd 0 DC {supply_v} AC 1
VREF vref 0 0.9
ITAIL ibias 0 200u
VLOAD vout load 0
ILOAD load 0 DC {load_a} AC 0
COUT vout 0 1u
XDUT vdd vout vref ibias 0 ldo_004_basic_pmos
.control
set noaskquit
set numdgt=12
op
let output_v=v(vout)
let tail_v=v(ibias)
let quiescent_a=-i(VDD)-i(VLOAD)
let power_w=-v(vdd)*i(VDD)-v(vref)*i(VREF)
print output_v tail_v quiescent_a power_w
write ldo-op.raw v(vout) v(ibias) v(vdd) v(vref) i(vdd) i(vref) i(vload)
ac dec 60 1 100meg
let rejection=-db(v(vout))
meas ac psrr_db find rejection at=1k
write ldo-supply.raw frequency v(vout) v(vdd)
alter @vdd[acmag] = 0
alter @iload[acmag] = 1
ac dec 60 1 100meg
let impedance=mag(v(vout))
meas ac dc_ohm find impedance at=1
meas ac peak_ohm max impedance from=1 to=100meg
let peaking_db=20*log10(peak_ohm/dc_ohm)
print peaking_db
write ldo-impedance.raw frequency v(vout) i(vload)
quit
.endc
.end
