* Derived from pinned analog-db; Copyright 2026 Danial Noori Zadeh.
* See collection license; 5 nm geometry, physical R/C, explicit interface.
.subckt cmp_002_strongarm vdd voutp voutn vinp vinn clk vss
MMINN_0 sp vinn tail vss nfet_03v3 w=8u l=0.28u
MMINN_1 sp vinn tail vss nfet_03v3 w=8u l=0.28u
MMINP_0 sn vinp tail vss nfet_03v3 w=8u l=0.28u
MMINP_1 sn vinp tail vss nfet_03v3 w=8u l=0.28u
MMLEM_0 lm lp sn vss nfet_03v3 w=4u l=0.28u
MMLEP_0 lp lm sp vss nfet_03v3 w=4u l=0.28u
MMLUM_0 lm lp vdd vdd pfet_03v3 w=4u l=0.28u
MMLUP_0 lp lm vdd vdd pfet_03v3 w=4u l=0.28u
MMOBN1_0 voutp lm vss vss nfet_03v3 w=1.5u l=0.28u
MMOBN2_0 voutn lp vss vss nfet_03v3 w=1.5u l=0.28u
MMOBP1_0 voutp lm vdd vdd pfet_03v3 w=3u l=0.28u
MMOBP2_0 voutn lp vdd vdd pfet_03v3 w=3u l=0.28u
MMPC1_0 sp clk vdd vdd pfet_03v3 w=2u l=0.28u
MMPC2_0 sn clk vdd vdd pfet_03v3 w=2u l=0.28u
MMPC3_0 lp clk vdd vdd pfet_03v3 w=2u l=0.28u
MMPC4_0 lm clk vdd vdd pfet_03v3 w=2u l=0.28u
MMTAIL_0 tail clk vss vss nfet_03v3 w=4u l=0.28u
.ends cmp_002_strongarm
