* Maintained Layout-Bench testbench. SPDX-License-Identifier: MIT
.include support/models.spice
.include dut.spice
.include parameters.spice
.temp 27
VDD vdd 0 DC {supply_v}
IB ibias 0 20u
* External bias fixture: DC output feedback, AC-isolated input injection.
LFB vout vinn 1T
VCM vinp 0 DC 1.65 AC 0.5
VB1 vb1 0 1.2
VB2 vb2 0 1.95
VIN acin 0 DC 0 AC 0.5 180
CIN acin vinn 1
CL vout 0 1p
XDUT vinn vinp vout vdd ibias 0 vb1 vb2 amp_004_folded_cascode
.control
set noaskquit
set numdgt=12
op
let output_v=v(vout)
let bias_v=v(ibias)
let power_w=-v(vdd)*i(vdd)
print output_v bias_v power_w
write op.raw v(vdd) v(vout) v(vinn) v(ibias) i(vdd)
ac dec 100 1 1G
let transfer=v(vout)/(v(vinp)-v(vinn))
let response_db=db(transfer)
meas ac gain_db find response_db at=10
let drop_db=db(transfer)-gain_db
meas ac bandwidth_hz when drop_db=-3 fall=1
let phase_deg=180*cph(transfer)/pi
meas ac unity_hz when response_db=0 fall=1
meas ac phase_unity find phase_deg when response_db=0 fall=1
let phase_margin=180+phase_unity
print phase_margin
write ac.raw frequency v(vout) v(vinn) v(vinp)
quit
.endc
.end
