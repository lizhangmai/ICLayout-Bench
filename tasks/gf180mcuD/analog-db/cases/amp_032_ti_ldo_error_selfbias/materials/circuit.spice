* Derived from pinned analog-db; Copyright 2026 Danial Noori Zadeh.
* See collection license; 5 nm geometry, physical R/C, explicit interface.
.subckt amp_032_ti_ldo_error_selfbias vdd vout vinp vinn vss
XCC_0 ncz vout cap_mim_2f0_m4m5_noshield c_width=20u c_length=19.735u
XCC_1 ncz vout cap_mim_2f0_m4m5_noshield c_width=20u c_length=19.735u
XCC_2 ncz vout cap_mim_2f0_m4m5_noshield c_width=20u c_length=19.735u
XCC_3 ncz vout cap_mim_2f0_m4m5_noshield c_width=20u c_length=19.735u
XCC_4 ncz vout cap_mim_2f0_m4m5_noshield c_width=20u c_length=19.735u
XCC_5 ncz vout cap_mim_2f0_m4m5_noshield c_width=20u c_length=19.735u
XCC_6 ncz vout cap_mim_2f0_m4m5_noshield c_width=20u c_length=19.735u
XCC_7 ncz vout cap_mim_2f0_m4m5_noshield c_width=20u c_length=19.735u
XCC_8 ncz vout cap_mim_2f0_m4m5_noshield c_width=20u c_length=19.735u
XCC_9 ncz vout cap_mim_2f0_m4m5_noshield c_width=20u c_length=19.735u
XCC_10 ncz vout cap_mim_2f0_m4m5_noshield c_width=20u c_length=19.735u
XCC_11 ncz vout cap_mim_2f0_m4m5_noshield c_width=20u c_length=19.735u
XCC_12 ncz vout cap_mim_2f0_m4m5_noshield c_width=20u c_length=19.735u
XCC_13 ncz vout cap_mim_2f0_m4m5_noshield c_width=20u c_length=19.735u
XCC_14 ncz vout cap_mim_2f0_m4m5_noshield c_width=20u c_length=19.735u
XCC_15 ncz vout cap_mim_2f0_m4m5_noshield c_width=20u c_length=19.735u
XCC_16 ncz vout cap_mim_2f0_m4m5_noshield c_width=20u c_length=19.735u
XCC_17 ncz vout cap_mim_2f0_m4m5_noshield c_width=20u c_length=19.735u
XCC_18 ncz vout cap_mim_2f0_m4m5_noshield c_width=20u c_length=19.735u
XRND_0 na RND_seg1 vss ppolyf_u_1k r_width=1u r_length=50u
XRND_1 RND_seg1 RND_seg2 vss ppolyf_u_1k r_width=1u r_length=50u
XRND_2 RND_seg2 RND_seg3 vss ppolyf_u_1k r_width=1u r_length=50u
XRND_3 RND_seg3 RND_seg4 vss ppolyf_u_1k r_width=1u r_length=50u
XRND_4 RND_seg4 RND_seg5 vss ppolyf_u_1k r_width=1u r_length=50u
XRND_5 RND_seg5 RND_seg6 vss ppolyf_u_1k r_width=1u r_length=50u
XRND_6 RND_seg6 RND_seg7 vss ppolyf_u_1k r_width=1u r_length=50u
XRND_7 RND_seg7 RND_seg8 vss ppolyf_u_1k r_width=1u r_length=50u
XRND_8 RND_seg8 RND_seg9 vss ppolyf_u_1k r_width=1u r_length=50u
XRND_9 RND_seg9 nd vss ppolyf_u_1k r_width=1u r_length=50u
XRZ_0 nb ncz vss ppolyf_u_1k r_width=1u r_length=10u
XM1_0 na vinn tail vss nfet_06v0 w=68.54u l=0.7u
XM2_0 nb vinp tail vss nfet_06v0 w=68.54u l=0.7u
XM3_0 na nd vdd vdd pfet_06v0 w=69.545u l=0.55u
XM4_0 nlev na nd vdd pfet_06v0 w=10u l=0.55u
XM5_0 nb nd vdd vdd pfet_06v0 w=69.545u l=0.55u
XM6_0 vout nb vdd vdd pfet_06v0 w=60u l=1u
XMB0_0 ibias ibias vss vss nfet_06v0 w=34.535u l=2u
XMBC_0 tail ibias vss vss nfet_06v0 w=34.535u l=2u
XMBF_0 nlev ibias vss vss nfet_06v0 w=5u l=2u
XMBO_0 vout ibias vss vss nfet_06v0 w=34.535u l=2u
XMBP_0 ibias ibias vdd vdd pfet_06v0 w=6.31u l=2u
.ends amp_032_ti_ldo_error_selfbias
