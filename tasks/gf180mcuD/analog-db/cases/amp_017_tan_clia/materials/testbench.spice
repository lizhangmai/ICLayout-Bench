* Same-condition finite-window amplifier observations. SPDX-License-Identifier: MIT
.include support/models.spice
.include parameters.spice
.include dut.spice
.temp 27
.save v(vdd) v(vout) v(vp) v(net1) i(VDD)
.option klu reltol=1e-5 abstol=1e-12 vntol=1e-8 method=gear maxord=2 itl4=1000
VDD vdd 0 1.8
VIN vp 0 dc 0.3 ac 1 pulse(0.3 { 0.3+step_v } 20u 100n 100n 80u 200u)
IBIAS net1 0 2.32803e-06
XDUT 0 vdd vout vp vout net1 amp_017_tan_clia
CLOAD vout 0 {load_f}
.control
set noaskquit
set num_threads=1
set numdgt=15
set measdgt=15
op
let output_v=v(vout)
let bias_v=v(net1)
let power_w=-v(vdd)*i(VDD)
print output_v bias_v power_w
write op.raw all
ac dec 200 1 1g
let closed_gain_db=db(v(vout))
meas ac closed_gain_10khz_db find closed_gain_db at=10k
write ac.raw all
tran 10n 200u 0 10n
let error_v=abs(v(vout)-v(vp))
let supply=-v(vdd)*i(VDD)
meas tran late_error_v avg error_v from=80u to=100u
meas tran return_error_v avg error_v from=180u to=200u
meas tran high_v avg v(vout) from=80u to=100u
meas tran low_v avg v(vout) from=180u to=200u
meas tran ripple_v pp v(vout) from=80u to=100u
meas tran return_ripple_v pp v(vout) from=180u to=200u
meas tran mean_power_w avg supply from=20u to=200u
meas tran output_min_v min v(vout) from=0 to=200u
meas tran output_max_v max v(vout) from=0 to=200u
write transient.raw v(vout) v(vp) i(VDD) error_v supply
quit
.endc
.end
