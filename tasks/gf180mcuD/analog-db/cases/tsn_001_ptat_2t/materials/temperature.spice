* Independently authored measurement fixture; SPDX-License-Identifier: MIT
.include support/models.spice
.include dut.spice
.include parameters.spice
.options pivtol=1e-30 pivrel=0.001 gmin=1e-18 reltol=1e-7 abstol=1e-18 vntol=1e-10
.temp 27
VDD vdd 0 1.2
VSS vss 0 0
RL vout 0 1e12
CL vout 0 1p
XDUT vdd vout vss tsn_001_ptat_2t
.nodeset v(vout)=0.05
.control
set numdgt=15
set measdgt=15
dc temp -20 120 5
let kcl_residual=abs(i(vdd)+i(vss)+v(vout)/1e12)
if maximum(kcl_residual) > 1e-14
  echo Error: temperature sweep KCL failed
  quit 1
end
let cold=v(vout)[0]
let hot=v(vout)[length(v(vout))-1]
let slope_v_c=(hot-cold)/140
let deviation=abs(v(vout)-cold-slope_v_c*("temp-sweep"+20))
let curvature_v=maximum(deviation)
print slope_v_c curvature_v
write temperature.raw all
dc temp 120 -20 -5
let kcl_residual=abs(i(vdd)+i(vss)+v(vout)/1e12)
if maximum(kcl_residual) > 1e-14
  echo Error: temperature sweep KCL failed
  quit 1
end
write reverse.raw all
quit
.endc
.end
