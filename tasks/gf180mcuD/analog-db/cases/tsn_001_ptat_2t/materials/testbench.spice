* Independently authored measurement fixture; SPDX-License-Identifier: MIT
.include support/models.spice
.include dut.spice
.include parameters.spice
.options pivtol=1e-30 pivrel=0.001 gmin=1e-18 reltol=1e-7 abstol=1e-18 vntol=1e-10
.temp {temperature}
VDD vdd 0 1.2
VSS vss 0 0
RL vout 0 1e12
CL vout 0 1p
XDUT vdd vout vss tsn_001_ptat_2t
.nodeset v(vout)=0.05
.control
set numdgt=15
set measdgt=15
op
let kcl_residual=abs(i(vdd)+i(vss)+v(vout)/1e12)
if kcl_residual > 1e-14
  echo Error: external DC KCL failed
  quit 1
end
let output_v=v(vout)
let power_w=-v(vdd)*i(vdd)
print output_v power_w
show all
write op.raw all
quit
.endc
.end
