* Required Notice: Copyright 2026 Danial Noori Zadeh
* Native physical adaptation; see collection LICENSE and NOTICE.
.subckt tsn_001_ptat_2t vdd vout vss
MM0_0 vdd vout vout vss nfet_03v3 w=8u l=0.28u
MM0_1 vdd vout vout vss nfet_03v3 w=8u l=0.28u
MM0_2 vdd vout vout vss nfet_03v3 w=8u l=0.28u
MM0_3 vdd vout vout vss nfet_03v3 w=8u l=0.28u
MM0_4 vdd vout vout vss nfet_03v3 w=8u l=0.28u
MM0_5 vdd vout vout vss nfet_03v3 w=8u l=0.28u
MM0_6 vdd vout vout vss nfet_03v3 w=8u l=0.28u
MM0_7 vdd vout vout vss nfet_03v3 w=8u l=0.28u
MM1_0 vout vout vss vss nfet_03v3 w=4u l=1u
MM1_1 vout vout vss vss nfet_03v3 w=4u l=1u
MM1_2 vout vout vss vss nfet_03v3 w=4u l=1u
MM1_3 vout vout vss vss nfet_03v3 w=4u l=1u
MM1_4 vout vout vss vss nfet_03v3 w=4u l=1u
MM1_5 vout vout vss vss nfet_03v3 w=4u l=1u
MM1_6 vout vout vss vss nfet_03v3 w=4u l=1u
MM1_7 vout vout vss vss nfet_03v3 w=4u l=1u
.ends tsn_001_ptat_2t
