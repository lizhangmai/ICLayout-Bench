* Required Notice: Copyright 2026 Danial Noori Zadeh
* Native physical adaptation; see collection LICENSE and NOTICE.
.subckt amp_019_ti_ldo_error vdd vout vinp vinn ibias vss
CC_0 ncz vout cap_mim_2f0fF w=20u l=19.53u
CC_1 ncz vout cap_mim_2f0fF w=20u l=19.53u
CC_2 ncz vout cap_mim_2f0fF w=20u l=19.53u
CC_3 ncz vout cap_mim_2f0fF w=20u l=19.53u
CC_4 ncz vout cap_mim_2f0fF w=20u l=19.53u
CC_5 ncz vout cap_mim_2f0fF w=20u l=19.53u
CC_6 ncz vout cap_mim_2f0fF w=20u l=19.53u
CC_7 ncz vout cap_mim_2f0fF w=20u l=19.53u
CC_8 ncz vout cap_mim_2f0fF w=20u l=19.53u
CC_9 ncz vout cap_mim_2f0fF w=20u l=19.53u
CC_10 ncz vout cap_mim_2f0fF w=20u l=19.53u
CC_11 ncz vout cap_mim_2f0fF w=20u l=19.53u
CC_12 ncz vout cap_mim_2f0fF w=20u l=19.53u
CC_13 ncz vout cap_mim_2f0fF w=20u l=19.53u
CC_14 ncz vout cap_mim_2f0fF w=20u l=19.53u
CC_15 ncz vout cap_mim_2f0fF w=20u l=19.53u
CC_16 ncz vout cap_mim_2f0fF w=20u l=19.53u
CC_17 ncz vout cap_mim_2f0fF w=20u l=19.53u
CC_18 ncz vout cap_mim_2f0fF w=20u l=19.53u
CC_19 ncz vout cap_mim_2f0fF w=20u l=19.53u
CC_20 ncz vout cap_mim_2f0fF w=20u l=19.53u
CC_21 ncz vout cap_mim_2f0fF w=20u l=19.53u
CC_22 ncz vout cap_mim_2f0fF w=20u l=19.53u
CC_23 ncz vout cap_mim_2f0fF w=20u l=19.53u
CC_24 ncz vout cap_mim_2f0fF w=20u l=19.53u
CC_25 ncz vout cap_mim_2f0fF w=20u l=19.53u
CC_26 ncz vout cap_mim_2f0fF w=20u l=19.53u
CC_27 ncz vout cap_mim_2f0fF w=20u l=19.53u
CC_28 ncz vout cap_mim_2f0fF w=20u l=19.53u
CC_29 ncz vout cap_mim_2f0fF w=20u l=19.53u
CC_30 ncz vout cap_mim_2f0fF w=20u l=19.53u
CC_31 ncz vout cap_mim_2f0fF w=20u l=19.53u
RND_0 na RND_seg1 vss ppolyf_u_1k w=1u l=48.44u
RND_1 RND_seg1 RND_seg2 vss ppolyf_u_1k w=1u l=48.44u
RND_2 RND_seg2 RND_seg3 vss ppolyf_u_1k w=1u l=48.44u
RND_3 RND_seg3 RND_seg4 vss ppolyf_u_1k w=1u l=48.44u
RND_4 RND_seg4 RND_seg5 vss ppolyf_u_1k w=1u l=48.44u
RND_5 RND_seg5 RND_seg6 vss ppolyf_u_1k w=1u l=48.44u
RND_6 RND_seg6 RND_seg7 vss ppolyf_u_1k w=1u l=48.44u
RND_7 RND_seg7 RND_seg8 vss ppolyf_u_1k w=1u l=48.44u
RND_8 RND_seg8 RND_seg9 vss ppolyf_u_1k w=1u l=48.44u
RND_9 RND_seg9 nd vss ppolyf_u_1k w=1u l=48.44u
MM1_0 na vinn tail vss nfet_06v0 w=40u l=0.7u
MM2_0 nb vinp tail vss nfet_06v0 w=40u l=0.7u
MM3_0 na nd vdd vdd pfet_06v0 w=100u l=0.55u
MM4_0 nlev na nd vdd pfet_06v0 w=10u l=0.55u
MM5_0 nb nd vdd vdd pfet_06v0 w=100u l=0.55u
MM6_0 vout ne vdd vdd pfet_06v0 w=100u l=0.55u
MM7_0 ne ne nb vdd pfet_06v0 w=40u l=0.55u
MMB0_0 ibias ibias vss vss nfet_06v0 w=10u l=2u
MMBC_0 tail ibias vss vss nfet_06v0 w=10u l=2u
MMBE_0 ne ibias vss vss nfet_06v0 w=0.4u l=2u
MMBF_0 nlev ibias vss vss nfet_06v0 w=5u l=2u
MMBO_0 vout ibias vss vss nfet_06v0 w=10u l=2u
RZ0_0 nb ncz vss ppolyf_u_1k w=1u l=1.66u
RZ1_0 nb ncz vss ppolyf_u_1k w=1u l=1.66u
RZ2_0 nb ncz vss ppolyf_u_1k w=1u l=1.66u
RZ3_0 nb ncz vss ppolyf_u_1k w=1u l=1.66u
.ends amp_019_ti_ldo_error
