* Maintained Layout-Bench testbench. SPDX-License-Identifier: MIT
.include support/models.spice
.include dut.spice
.include parameters.spice
.temp 27
VDD vdd 0 {supply_v}
IB vdd ibias 20u
VPC vdd gate_pc 1.143
VNC casc_n tail 0.917
VP vinp 0 DC 1.65 AC 0.5
VN acn 0 DC 1.65 AC 0.5 180
LFB vout vinn 1T
CIN acn vinn 1
CL vout 0 {load_f}
XD vdd vout vinp vinn ibias 0 gate_pc casc_n tail amp_018_telescopic_cascode
.control
set noaskquit
set numdgt=12
op
let output_v=v(vout)
let bias_v=v(ibias)
let tail_v=v(tail)
let power_w=-v(vdd)*i(vdd)-(v(vdd)-v(gate_pc))*i(vpc)-(v(casc_n)-v(tail))*i(vnc)
print output_v bias_v tail_v power_w
write op.raw all
ac dec 100 1 1G
let transfer=v(vout)/(v(vinp)-v(vinn))
let gain_curve=db(transfer)
let phase_curve=180/PI*cph(transfer)
meas ac gain_db find gain_curve at=10
meas ac unity_hz when gain_curve=0 fall=1
meas ac phase_deg find phase_curve when gain_curve=0 fall=1
let phase_margin=180+phase_deg
print phase_margin
write ac.raw all
quit
.endc
.end
