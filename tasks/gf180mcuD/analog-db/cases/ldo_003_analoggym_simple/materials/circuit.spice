* Required Notice: Copyright 2026 Danial Noori Zadeh
* Native physical adaptation; see collection LICENSE and NOTICE.
.subckt ldo_003_analoggym_simple vdd vout vss vb vref
XCC_0 ncz vout cap_mim_2f0_m4m5_noshield c_width=20u c_length=12.5u
XCC_1 ncz vout cap_mim_2f0_m4m5_noshield c_width=20u c_length=12.5u
XRZ_0 ncz ngate vss ppolyf_u_1k r_width=1u r_length=2.75u
XR_BLEED_0 vout R_BLEED_seg1 vss ppolyf_u_1k r_width=1u r_length=48.44u
XR_BLEED_1 R_BLEED_seg1 vss vss ppolyf_u_1k r_width=1u r_length=48.44u
XM1_0 ndiode vout ntail vss nfet_06v0 w=2u l=2u
XM2_0 ngate vref ntail vss nfet_06v0 w=2u l=2u
XM3_0 ngate ndiode vdd vdd pfet_06v0 w=80u l=0.55u
XM4_0 ndiode ndiode vdd vdd pfet_06v0 w=80u l=0.55u
XM5_0 ntail vb vss vss nfet_06v0 w=100u l=0.7u
XMP_0 vout ngate vdd vdd pfet_06v0 w=20u l=0.55u
XMP_1 vout ngate vdd vdd pfet_06v0 w=20u l=0.55u
XMP_2 vout ngate vdd vdd pfet_06v0 w=20u l=0.55u
XMP_3 vout ngate vdd vdd pfet_06v0 w=20u l=0.55u
XMP_4 vout ngate vdd vdd pfet_06v0 w=20u l=0.55u
XMP_5 vout ngate vdd vdd pfet_06v0 w=20u l=0.55u
XMP_6 vout ngate vdd vdd pfet_06v0 w=20u l=0.55u
XMP_7 vout ngate vdd vdd pfet_06v0 w=20u l=0.55u
XMP_8 vout ngate vdd vdd pfet_06v0 w=20u l=0.55u
XMP_9 vout ngate vdd vdd pfet_06v0 w=20u l=0.55u
XMP_10 vout ngate vdd vdd pfet_06v0 w=20u l=0.55u
XMP_11 vout ngate vdd vdd pfet_06v0 w=20u l=0.55u
XMP_12 vout ngate vdd vdd pfet_06v0 w=20u l=0.55u
XMP_13 vout ngate vdd vdd pfet_06v0 w=20u l=0.55u
XMP_14 vout ngate vdd vdd pfet_06v0 w=20u l=0.55u
XMP_15 vout ngate vdd vdd pfet_06v0 w=20u l=0.55u
XMP_16 vout ngate vdd vdd pfet_06v0 w=20u l=0.55u
XMP_17 vout ngate vdd vdd pfet_06v0 w=20u l=0.55u
XMP_18 vout ngate vdd vdd pfet_06v0 w=20u l=0.55u
XMP_19 vout ngate vdd vdd pfet_06v0 w=20u l=0.55u
XMP_20 vout ngate vdd vdd pfet_06v0 w=20u l=0.55u
XMP_21 vout ngate vdd vdd pfet_06v0 w=20u l=0.55u
XMP_22 vout ngate vdd vdd pfet_06v0 w=20u l=0.55u
XMP_23 vout ngate vdd vdd pfet_06v0 w=20u l=0.55u
XMP_24 vout ngate vdd vdd pfet_06v0 w=20u l=0.55u
XMP_25 vout ngate vdd vdd pfet_06v0 w=20u l=0.55u
XMP_26 vout ngate vdd vdd pfet_06v0 w=20u l=0.55u
XMP_27 vout ngate vdd vdd pfet_06v0 w=20u l=0.55u
XMP_28 vout ngate vdd vdd pfet_06v0 w=20u l=0.55u
XMP_29 vout ngate vdd vdd pfet_06v0 w=20u l=0.55u
XMP_30 vout ngate vdd vdd pfet_06v0 w=20u l=0.55u
XMP_31 vout ngate vdd vdd pfet_06v0 w=20u l=0.55u
XMP_32 vout ngate vdd vdd pfet_06v0 w=20u l=0.55u
XMP_33 vout ngate vdd vdd pfet_06v0 w=20u l=0.55u
XMP_34 vout ngate vdd vdd pfet_06v0 w=20u l=0.55u
XMP_35 vout ngate vdd vdd pfet_06v0 w=20u l=0.55u
XMP_36 vout ngate vdd vdd pfet_06v0 w=20u l=0.55u
XMP_37 vout ngate vdd vdd pfet_06v0 w=20u l=0.55u
XMP_38 vout ngate vdd vdd pfet_06v0 w=20u l=0.55u
XMP_39 vout ngate vdd vdd pfet_06v0 w=20u l=0.55u
XMP_40 vout ngate vdd vdd pfet_06v0 w=20u l=0.55u
XMP_41 vout ngate vdd vdd pfet_06v0 w=20u l=0.55u
XMP_42 vout ngate vdd vdd pfet_06v0 w=20u l=0.55u
XMP_43 vout ngate vdd vdd pfet_06v0 w=20u l=0.55u
XMP_44 vout ngate vdd vdd pfet_06v0 w=20u l=0.55u
XMP_45 vout ngate vdd vdd pfet_06v0 w=20u l=0.55u
XMP_46 vout ngate vdd vdd pfet_06v0 w=20u l=0.55u
XMP_47 vout ngate vdd vdd pfet_06v0 w=20u l=0.55u
XMP_48 vout ngate vdd vdd pfet_06v0 w=20u l=0.55u
XMP_49 vout ngate vdd vdd pfet_06v0 w=20u l=0.55u
XMP_50 vout ngate vdd vdd pfet_06v0 w=20u l=0.55u
XMP_51 vout ngate vdd vdd pfet_06v0 w=20u l=0.55u
XMP_52 vout ngate vdd vdd pfet_06v0 w=20u l=0.55u
XMP_53 vout ngate vdd vdd pfet_06v0 w=20u l=0.55u
XMP_54 vout ngate vdd vdd pfet_06v0 w=20u l=0.55u
XMP_55 vout ngate vdd vdd pfet_06v0 w=20u l=0.55u
XMP_56 vout ngate vdd vdd pfet_06v0 w=20u l=0.55u
XMP_57 vout ngate vdd vdd pfet_06v0 w=20u l=0.55u
XMP_58 vout ngate vdd vdd pfet_06v0 w=20u l=0.55u
XMP_59 vout ngate vdd vdd pfet_06v0 w=20u l=0.55u
XMP_60 vout ngate vdd vdd pfet_06v0 w=20u l=0.55u
XMP_61 vout ngate vdd vdd pfet_06v0 w=20u l=0.55u
XMP_62 vout ngate vdd vdd pfet_06v0 w=20u l=0.55u
XMP_63 vout ngate vdd vdd pfet_06v0 w=20u l=0.55u
XMP_64 vout ngate vdd vdd pfet_06v0 w=20u l=0.55u
XMP_65 vout ngate vdd vdd pfet_06v0 w=20u l=0.55u
XMP_66 vout ngate vdd vdd pfet_06v0 w=20u l=0.55u
XMP_67 vout ngate vdd vdd pfet_06v0 w=20u l=0.55u
XMP_68 vout ngate vdd vdd pfet_06v0 w=20u l=0.55u
XMP_69 vout ngate vdd vdd pfet_06v0 w=20u l=0.55u
XMP_70 vout ngate vdd vdd pfet_06v0 w=20u l=0.55u
XMP_71 vout ngate vdd vdd pfet_06v0 w=20u l=0.55u
XMP_72 vout ngate vdd vdd pfet_06v0 w=20u l=0.55u
XMP_73 vout ngate vdd vdd pfet_06v0 w=20u l=0.55u
XMP_74 vout ngate vdd vdd pfet_06v0 w=20u l=0.55u
XMP_75 vout ngate vdd vdd pfet_06v0 w=20u l=0.55u
XMP_76 vout ngate vdd vdd pfet_06v0 w=20u l=0.55u
XMP_77 vout ngate vdd vdd pfet_06v0 w=20u l=0.55u
XMP_78 vout ngate vdd vdd pfet_06v0 w=20u l=0.55u
XMP_79 vout ngate vdd vdd pfet_06v0 w=20u l=0.55u
XMP_80 vout ngate vdd vdd pfet_06v0 w=20u l=0.55u
XMP_81 vout ngate vdd vdd pfet_06v0 w=20u l=0.55u
XMP_82 vout ngate vdd vdd pfet_06v0 w=20u l=0.55u
XMP_83 vout ngate vdd vdd pfet_06v0 w=20u l=0.55u
XMP_84 vout ngate vdd vdd pfet_06v0 w=20u l=0.55u
XMP_85 vout ngate vdd vdd pfet_06v0 w=20u l=0.55u
XMP_86 vout ngate vdd vdd pfet_06v0 w=20u l=0.55u
XMP_87 vout ngate vdd vdd pfet_06v0 w=20u l=0.55u
XMP_88 vout ngate vdd vdd pfet_06v0 w=20u l=0.55u
XMP_89 vout ngate vdd vdd pfet_06v0 w=20u l=0.55u
XMP_90 vout ngate vdd vdd pfet_06v0 w=20u l=0.55u
XMP_91 vout ngate vdd vdd pfet_06v0 w=20u l=0.55u
XMP_92 vout ngate vdd vdd pfet_06v0 w=20u l=0.55u
XMP_93 vout ngate vdd vdd pfet_06v0 w=20u l=0.55u
XMP_94 vout ngate vdd vdd pfet_06v0 w=20u l=0.55u
XMP_95 vout ngate vdd vdd pfet_06v0 w=20u l=0.55u
XMP_96 vout ngate vdd vdd pfet_06v0 w=20u l=0.55u
XMP_97 vout ngate vdd vdd pfet_06v0 w=20u l=0.55u
XMP_98 vout ngate vdd vdd pfet_06v0 w=20u l=0.55u
XMP_99 vout ngate vdd vdd pfet_06v0 w=20u l=0.55u
XMP_100 vout ngate vdd vdd pfet_06v0 w=20u l=0.55u
XMP_101 vout ngate vdd vdd pfet_06v0 w=20u l=0.55u
XMP_102 vout ngate vdd vdd pfet_06v0 w=20u l=0.55u
XMP_103 vout ngate vdd vdd pfet_06v0 w=20u l=0.55u
XMP_104 vout ngate vdd vdd pfet_06v0 w=20u l=0.55u
XMP_105 vout ngate vdd vdd pfet_06v0 w=20u l=0.55u
XMP_106 vout ngate vdd vdd pfet_06v0 w=20u l=0.55u
XMP_107 vout ngate vdd vdd pfet_06v0 w=20u l=0.55u
XMP_108 vout ngate vdd vdd pfet_06v0 w=20u l=0.55u
XMP_109 vout ngate vdd vdd pfet_06v0 w=20u l=0.55u
XMP_110 vout ngate vdd vdd pfet_06v0 w=20u l=0.55u
XMP_111 vout ngate vdd vdd pfet_06v0 w=20u l=0.55u
XMP_112 vout ngate vdd vdd pfet_06v0 w=20u l=0.55u
XMP_113 vout ngate vdd vdd pfet_06v0 w=20u l=0.55u
XMP_114 vout ngate vdd vdd pfet_06v0 w=20u l=0.55u
XMP_115 vout ngate vdd vdd pfet_06v0 w=20u l=0.55u
XMP_116 vout ngate vdd vdd pfet_06v0 w=20u l=0.55u
XMP_117 vout ngate vdd vdd pfet_06v0 w=20u l=0.55u
XMP_118 vout ngate vdd vdd pfet_06v0 w=20u l=0.55u
XMP_119 vout ngate vdd vdd pfet_06v0 w=20u l=0.55u
XMP_120 vout ngate vdd vdd pfet_06v0 w=20u l=0.55u
XMP_121 vout ngate vdd vdd pfet_06v0 w=20u l=0.55u
XMP_122 vout ngate vdd vdd pfet_06v0 w=20u l=0.55u
XMP_123 vout ngate vdd vdd pfet_06v0 w=20u l=0.55u
XMP_124 vout ngate vdd vdd pfet_06v0 w=20u l=0.55u
XMP_125 vout ngate vdd vdd pfet_06v0 w=20u l=0.55u
XMP_126 vout ngate vdd vdd pfet_06v0 w=20u l=0.55u
XMP_127 vout ngate vdd vdd pfet_06v0 w=20u l=0.55u
XMP_128 vout ngate vdd vdd pfet_06v0 w=20u l=0.55u
XMP_129 vout ngate vdd vdd pfet_06v0 w=20u l=0.55u
XMP_130 vout ngate vdd vdd pfet_06v0 w=20u l=0.55u
XMP_131 vout ngate vdd vdd pfet_06v0 w=20u l=0.55u
XMP_132 vout ngate vdd vdd pfet_06v0 w=20u l=0.55u
XMP_133 vout ngate vdd vdd pfet_06v0 w=20u l=0.55u
XMP_134 vout ngate vdd vdd pfet_06v0 w=20u l=0.55u
XMP_135 vout ngate vdd vdd pfet_06v0 w=20u l=0.55u
XMP_136 vout ngate vdd vdd pfet_06v0 w=20u l=0.55u
XMP_137 vout ngate vdd vdd pfet_06v0 w=20u l=0.55u
XMP_138 vout ngate vdd vdd pfet_06v0 w=20u l=0.55u
XMP_139 vout ngate vdd vdd pfet_06v0 w=20u l=0.55u
XMP_140 vout ngate vdd vdd pfet_06v0 w=20u l=0.55u
XMP_141 vout ngate vdd vdd pfet_06v0 w=20u l=0.55u
XMP_142 vout ngate vdd vdd pfet_06v0 w=20u l=0.55u
XMP_143 vout ngate vdd vdd pfet_06v0 w=20u l=0.55u
XMP_144 vout ngate vdd vdd pfet_06v0 w=20u l=0.55u
XMP_145 vout ngate vdd vdd pfet_06v0 w=20u l=0.55u
XMP_146 vout ngate vdd vdd pfet_06v0 w=20u l=0.55u
XMP_147 vout ngate vdd vdd pfet_06v0 w=20u l=0.55u
XMP_148 vout ngate vdd vdd pfet_06v0 w=20u l=0.55u
XMP_149 vout ngate vdd vdd pfet_06v0 w=20u l=0.55u
XMP_150 vout ngate vdd vdd pfet_06v0 w=20u l=0.55u
XMP_151 vout ngate vdd vdd pfet_06v0 w=20u l=0.55u
XMP_152 vout ngate vdd vdd pfet_06v0 w=20u l=0.55u
XMP_153 vout ngate vdd vdd pfet_06v0 w=20u l=0.55u
XMP_154 vout ngate vdd vdd pfet_06v0 w=20u l=0.55u
XMP_155 vout ngate vdd vdd pfet_06v0 w=20u l=0.55u
XMP_156 vout ngate vdd vdd pfet_06v0 w=20u l=0.55u
XMP_157 vout ngate vdd vdd pfet_06v0 w=20u l=0.55u
XMP_158 vout ngate vdd vdd pfet_06v0 w=20u l=0.55u
XMP_159 vout ngate vdd vdd pfet_06v0 w=20u l=0.55u
XMP_160 vout ngate vdd vdd pfet_06v0 w=20u l=0.55u
XMP_161 vout ngate vdd vdd pfet_06v0 w=20u l=0.55u
XMP_162 vout ngate vdd vdd pfet_06v0 w=20u l=0.55u
XMP_163 vout ngate vdd vdd pfet_06v0 w=20u l=0.55u
XMP_164 vout ngate vdd vdd pfet_06v0 w=20u l=0.55u
XMP_165 vout ngate vdd vdd pfet_06v0 w=20u l=0.55u
XMP_166 vout ngate vdd vdd pfet_06v0 w=20u l=0.55u
XMP_167 vout ngate vdd vdd pfet_06v0 w=20u l=0.55u
XMP_168 vout ngate vdd vdd pfet_06v0 w=20u l=0.55u
XMP_169 vout ngate vdd vdd pfet_06v0 w=20u l=0.55u
XMP_170 vout ngate vdd vdd pfet_06v0 w=20u l=0.55u
XMP_171 vout ngate vdd vdd pfet_06v0 w=20u l=0.55u
XMP_172 vout ngate vdd vdd pfet_06v0 w=20u l=0.55u
XMP_173 vout ngate vdd vdd pfet_06v0 w=20u l=0.55u
XMP_174 vout ngate vdd vdd pfet_06v0 w=20u l=0.55u
XMP_175 vout ngate vdd vdd pfet_06v0 w=20u l=0.55u
XMP_176 vout ngate vdd vdd pfet_06v0 w=20u l=0.55u
XMP_177 vout ngate vdd vdd pfet_06v0 w=20u l=0.55u
XMP_178 vout ngate vdd vdd pfet_06v0 w=20u l=0.55u
XMP_179 vout ngate vdd vdd pfet_06v0 w=20u l=0.55u
XMP_180 vout ngate vdd vdd pfet_06v0 w=20u l=0.55u
XMP_181 vout ngate vdd vdd pfet_06v0 w=20u l=0.55u
XMP_182 vout ngate vdd vdd pfet_06v0 w=20u l=0.55u
XMP_183 vout ngate vdd vdd pfet_06v0 w=20u l=0.55u
XMP_184 vout ngate vdd vdd pfet_06v0 w=20u l=0.55u
XMP_185 vout ngate vdd vdd pfet_06v0 w=20u l=0.55u
XMP_186 vout ngate vdd vdd pfet_06v0 w=20u l=0.55u
XMP_187 vout ngate vdd vdd pfet_06v0 w=20u l=0.55u
XMP_188 vout ngate vdd vdd pfet_06v0 w=20u l=0.55u
XMP_189 vout ngate vdd vdd pfet_06v0 w=20u l=0.55u
XMP_190 vout ngate vdd vdd pfet_06v0 w=20u l=0.55u
XMP_191 vout ngate vdd vdd pfet_06v0 w=20u l=0.55u
XMP_192 vout ngate vdd vdd pfet_06v0 w=20u l=0.55u
XMP_193 vout ngate vdd vdd pfet_06v0 w=20u l=0.55u
XMP_194 vout ngate vdd vdd pfet_06v0 w=20u l=0.55u
XMP_195 vout ngate vdd vdd pfet_06v0 w=20u l=0.55u
XMP_196 vout ngate vdd vdd pfet_06v0 w=20u l=0.55u
XMP_197 vout ngate vdd vdd pfet_06v0 w=20u l=0.55u
XMP_198 vout ngate vdd vdd pfet_06v0 w=20u l=0.55u
XMP_199 vout ngate vdd vdd pfet_06v0 w=20u l=0.55u
XMP_200 vout ngate vdd vdd pfet_06v0 w=20u l=0.55u
XMP_201 vout ngate vdd vdd pfet_06v0 w=20u l=0.55u
XMP_202 vout ngate vdd vdd pfet_06v0 w=20u l=0.55u
XMP_203 vout ngate vdd vdd pfet_06v0 w=20u l=0.55u
XMP_204 vout ngate vdd vdd pfet_06v0 w=20u l=0.55u
XMP_205 vout ngate vdd vdd pfet_06v0 w=20u l=0.55u
XMP_206 vout ngate vdd vdd pfet_06v0 w=20u l=0.55u
XMP_207 vout ngate vdd vdd pfet_06v0 w=20u l=0.55u
XMP_208 vout ngate vdd vdd pfet_06v0 w=20u l=0.55u
XMP_209 vout ngate vdd vdd pfet_06v0 w=20u l=0.55u
XMP_210 vout ngate vdd vdd pfet_06v0 w=20u l=0.55u
XMP_211 vout ngate vdd vdd pfet_06v0 w=20u l=0.55u
XMP_212 vout ngate vdd vdd pfet_06v0 w=20u l=0.55u
XMP_213 vout ngate vdd vdd pfet_06v0 w=20u l=0.55u
XMP_214 vout ngate vdd vdd pfet_06v0 w=20u l=0.55u
XMP_215 vout ngate vdd vdd pfet_06v0 w=20u l=0.55u
XMP_216 vout ngate vdd vdd pfet_06v0 w=20u l=0.55u
XMP_217 vout ngate vdd vdd pfet_06v0 w=20u l=0.55u
XMP_218 vout ngate vdd vdd pfet_06v0 w=20u l=0.55u
XMP_219 vout ngate vdd vdd pfet_06v0 w=20u l=0.55u
XMP_220 vout ngate vdd vdd pfet_06v0 w=20u l=0.55u
XMP_221 vout ngate vdd vdd pfet_06v0 w=20u l=0.55u
XMP_222 vout ngate vdd vdd pfet_06v0 w=20u l=0.55u
XMP_223 vout ngate vdd vdd pfet_06v0 w=20u l=0.55u
XMP_224 vout ngate vdd vdd pfet_06v0 w=20u l=0.55u
XMP_225 vout ngate vdd vdd pfet_06v0 w=20u l=0.55u
XMP_226 vout ngate vdd vdd pfet_06v0 w=20u l=0.55u
XMP_227 vout ngate vdd vdd pfet_06v0 w=20u l=0.55u
XMP_228 vout ngate vdd vdd pfet_06v0 w=20u l=0.55u
XMP_229 vout ngate vdd vdd pfet_06v0 w=20u l=0.55u
XMP_230 vout ngate vdd vdd pfet_06v0 w=20u l=0.55u
XMP_231 vout ngate vdd vdd pfet_06v0 w=20u l=0.55u
XMP_232 vout ngate vdd vdd pfet_06v0 w=20u l=0.55u
XMP_233 vout ngate vdd vdd pfet_06v0 w=20u l=0.55u
XMP_234 vout ngate vdd vdd pfet_06v0 w=20u l=0.55u
XMP_235 vout ngate vdd vdd pfet_06v0 w=20u l=0.55u
XMP_236 vout ngate vdd vdd pfet_06v0 w=20u l=0.55u
XMP_237 vout ngate vdd vdd pfet_06v0 w=20u l=0.55u
XMP_238 vout ngate vdd vdd pfet_06v0 w=20u l=0.55u
XMP_239 vout ngate vdd vdd pfet_06v0 w=20u l=0.55u
XMP_240 vout ngate vdd vdd pfet_06v0 w=20u l=0.55u
XMP_241 vout ngate vdd vdd pfet_06v0 w=20u l=0.55u
XMP_242 vout ngate vdd vdd pfet_06v0 w=20u l=0.55u
XMP_243 vout ngate vdd vdd pfet_06v0 w=20u l=0.55u
XMP_244 vout ngate vdd vdd pfet_06v0 w=20u l=0.55u
XMP_245 vout ngate vdd vdd pfet_06v0 w=20u l=0.55u
XMP_246 vout ngate vdd vdd pfet_06v0 w=20u l=0.55u
XMP_247 vout ngate vdd vdd pfet_06v0 w=20u l=0.55u
XMP_248 vout ngate vdd vdd pfet_06v0 w=20u l=0.55u
XMP_249 vout ngate vdd vdd pfet_06v0 w=20u l=0.55u
XMP_250 vout ngate vdd vdd pfet_06v0 w=20u l=0.55u
XMP_251 vout ngate vdd vdd pfet_06v0 w=20u l=0.55u
XMP_252 vout ngate vdd vdd pfet_06v0 w=20u l=0.55u
XMP_253 vout ngate vdd vdd pfet_06v0 w=20u l=0.55u
XMP_254 vout ngate vdd vdd pfet_06v0 w=20u l=0.55u
XMP_255 vout ngate vdd vdd pfet_06v0 w=20u l=0.55u
XMP_256 vout ngate vdd vdd pfet_06v0 w=20u l=0.55u
XMP_257 vout ngate vdd vdd pfet_06v0 w=20u l=0.55u
XMP_258 vout ngate vdd vdd pfet_06v0 w=20u l=0.55u
XMP_259 vout ngate vdd vdd pfet_06v0 w=20u l=0.55u
XMP_260 vout ngate vdd vdd pfet_06v0 w=20u l=0.55u
XMP_261 vout ngate vdd vdd pfet_06v0 w=20u l=0.55u
XMP_262 vout ngate vdd vdd pfet_06v0 w=20u l=0.55u
XMP_263 vout ngate vdd vdd pfet_06v0 w=20u l=0.55u
XMP_264 vout ngate vdd vdd pfet_06v0 w=20u l=0.55u
XMP_265 vout ngate vdd vdd pfet_06v0 w=20u l=0.55u
XMP_266 vout ngate vdd vdd pfet_06v0 w=20u l=0.55u
XMP_267 vout ngate vdd vdd pfet_06v0 w=20u l=0.55u
XMP_268 vout ngate vdd vdd pfet_06v0 w=20u l=0.55u
XMP_269 vout ngate vdd vdd pfet_06v0 w=20u l=0.55u
XMP_270 vout ngate vdd vdd pfet_06v0 w=20u l=0.55u
XMP_271 vout ngate vdd vdd pfet_06v0 w=20u l=0.55u
XMP_272 vout ngate vdd vdd pfet_06v0 w=20u l=0.55u
XMP_273 vout ngate vdd vdd pfet_06v0 w=20u l=0.55u
XMP_274 vout ngate vdd vdd pfet_06v0 w=20u l=0.55u
XMP_275 vout ngate vdd vdd pfet_06v0 w=20u l=0.55u
XMP_276 vout ngate vdd vdd pfet_06v0 w=20u l=0.55u
XMP_277 vout ngate vdd vdd pfet_06v0 w=20u l=0.55u
XMP_278 vout ngate vdd vdd pfet_06v0 w=20u l=0.55u
XMP_279 vout ngate vdd vdd pfet_06v0 w=20u l=0.55u
XMP_280 vout ngate vdd vdd pfet_06v0 w=20u l=0.55u
XMP_281 vout ngate vdd vdd pfet_06v0 w=20u l=0.55u
XMP_282 vout ngate vdd vdd pfet_06v0 w=20u l=0.55u
XMP_283 vout ngate vdd vdd pfet_06v0 w=20u l=0.55u
XMP_284 vout ngate vdd vdd pfet_06v0 w=20u l=0.55u
XMP_285 vout ngate vdd vdd pfet_06v0 w=20u l=0.55u
XMP_286 vout ngate vdd vdd pfet_06v0 w=20u l=0.55u
XMP_287 vout ngate vdd vdd pfet_06v0 w=20u l=0.55u
XMP_288 vout ngate vdd vdd pfet_06v0 w=20u l=0.55u
XMP_289 vout ngate vdd vdd pfet_06v0 w=20u l=0.55u
XMP_290 vout ngate vdd vdd pfet_06v0 w=20u l=0.55u
XMP_291 vout ngate vdd vdd pfet_06v0 w=20u l=0.55u
XMP_292 vout ngate vdd vdd pfet_06v0 w=20u l=0.55u
XMP_293 vout ngate vdd vdd pfet_06v0 w=20u l=0.55u
XMP_294 vout ngate vdd vdd pfet_06v0 w=20u l=0.55u
XMP_295 vout ngate vdd vdd pfet_06v0 w=20u l=0.55u
XMP_296 vout ngate vdd vdd pfet_06v0 w=20u l=0.55u
XMP_297 vout ngate vdd vdd pfet_06v0 w=20u l=0.55u
XMP_298 vout ngate vdd vdd pfet_06v0 w=20u l=0.55u
XMP_299 vout ngate vdd vdd pfet_06v0 w=20u l=0.55u
XMP_300 vout ngate vdd vdd pfet_06v0 w=20u l=0.55u
XMP_301 vout ngate vdd vdd pfet_06v0 w=20u l=0.55u
XMP_302 vout ngate vdd vdd pfet_06v0 w=20u l=0.55u
XMP_303 vout ngate vdd vdd pfet_06v0 w=20u l=0.55u
XMP_304 vout ngate vdd vdd pfet_06v0 w=20u l=0.55u
XMP_305 vout ngate vdd vdd pfet_06v0 w=20u l=0.55u
XMP_306 vout ngate vdd vdd pfet_06v0 w=20u l=0.55u
XMP_307 vout ngate vdd vdd pfet_06v0 w=20u l=0.55u
XMP_308 vout ngate vdd vdd pfet_06v0 w=20u l=0.55u
XMP_309 vout ngate vdd vdd pfet_06v0 w=20u l=0.55u
XMP_310 vout ngate vdd vdd pfet_06v0 w=20u l=0.55u
XMP_311 vout ngate vdd vdd pfet_06v0 w=20u l=0.55u
XMP_312 vout ngate vdd vdd pfet_06v0 w=20u l=0.55u
XMP_313 vout ngate vdd vdd pfet_06v0 w=20u l=0.55u
XMP_314 vout ngate vdd vdd pfet_06v0 w=20u l=0.55u
XMP_315 vout ngate vdd vdd pfet_06v0 w=20u l=0.55u
XMP_316 vout ngate vdd vdd pfet_06v0 w=20u l=0.55u
XMP_317 vout ngate vdd vdd pfet_06v0 w=20u l=0.55u
XMP_318 vout ngate vdd vdd pfet_06v0 w=20u l=0.55u
XMP_319 vout ngate vdd vdd pfet_06v0 w=20u l=0.55u
XMP_320 vout ngate vdd vdd pfet_06v0 w=20u l=0.55u
XMP_321 vout ngate vdd vdd pfet_06v0 w=20u l=0.55u
XMP_322 vout ngate vdd vdd pfet_06v0 w=20u l=0.55u
XMP_323 vout ngate vdd vdd pfet_06v0 w=20u l=0.55u
XMP_324 vout ngate vdd vdd pfet_06v0 w=20u l=0.55u
XMP_325 vout ngate vdd vdd pfet_06v0 w=20u l=0.55u
XMP_326 vout ngate vdd vdd pfet_06v0 w=20u l=0.55u
XMP_327 vout ngate vdd vdd pfet_06v0 w=20u l=0.55u
XMP_328 vout ngate vdd vdd pfet_06v0 w=20u l=0.55u
XMP_329 vout ngate vdd vdd pfet_06v0 w=20u l=0.55u
XMP_330 vout ngate vdd vdd pfet_06v0 w=20u l=0.55u
XMP_331 vout ngate vdd vdd pfet_06v0 w=20u l=0.55u
XMP_332 vout ngate vdd vdd pfet_06v0 w=20u l=0.55u
XMP_333 vout ngate vdd vdd pfet_06v0 w=20u l=0.55u
XMP_334 vout ngate vdd vdd pfet_06v0 w=20u l=0.55u
XMP_335 vout ngate vdd vdd pfet_06v0 w=20u l=0.55u
XMP_336 vout ngate vdd vdd pfet_06v0 w=20u l=0.55u
XMP_337 vout ngate vdd vdd pfet_06v0 w=20u l=0.55u
XMP_338 vout ngate vdd vdd pfet_06v0 w=20u l=0.55u
XMP_339 vout ngate vdd vdd pfet_06v0 w=20u l=0.55u
XMP_340 vout ngate vdd vdd pfet_06v0 w=20u l=0.55u
XMP_341 vout ngate vdd vdd pfet_06v0 w=20u l=0.55u
XMP_342 vout ngate vdd vdd pfet_06v0 w=20u l=0.55u
XMP_343 vout ngate vdd vdd pfet_06v0 w=20u l=0.55u
XMP_344 vout ngate vdd vdd pfet_06v0 w=20u l=0.55u
XMP_345 vout ngate vdd vdd pfet_06v0 w=20u l=0.55u
XMP_346 vout ngate vdd vdd pfet_06v0 w=20u l=0.55u
XMP_347 vout ngate vdd vdd pfet_06v0 w=20u l=0.55u
XMP_348 vout ngate vdd vdd pfet_06v0 w=20u l=0.55u
XMP_349 vout ngate vdd vdd pfet_06v0 w=20u l=0.55u
XMP_350 vout ngate vdd vdd pfet_06v0 w=20u l=0.55u
XMP_351 vout ngate vdd vdd pfet_06v0 w=20u l=0.55u
XMP_352 vout ngate vdd vdd pfet_06v0 w=20u l=0.55u
XMP_353 vout ngate vdd vdd pfet_06v0 w=20u l=0.55u
XMP_354 vout ngate vdd vdd pfet_06v0 w=20u l=0.55u
XMP_355 vout ngate vdd vdd pfet_06v0 w=20u l=0.55u
XMP_356 vout ngate vdd vdd pfet_06v0 w=20u l=0.55u
XMP_357 vout ngate vdd vdd pfet_06v0 w=20u l=0.55u
XMP_358 vout ngate vdd vdd pfet_06v0 w=20u l=0.55u
XMP_359 vout ngate vdd vdd pfet_06v0 w=20u l=0.55u
.ends ldo_003_analoggym_simple
