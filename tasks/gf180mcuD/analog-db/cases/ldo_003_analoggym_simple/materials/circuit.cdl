* Required Notice: Copyright 2026 Danial Noori Zadeh
* Native physical adaptation; see collection LICENSE and NOTICE.
.subckt ldo_003_analoggym_simple vdd vout vss vb vref
CC_0 ncz vout cap_mim_2f0fF w=20u l=12.5u
CC_1 ncz vout cap_mim_2f0fF w=20u l=12.5u
RZ_0 ncz ngate vss ppolyf_u_1k w=1u l=2.75u
R_BLEED_0 vout R_BLEED_seg1 vss ppolyf_u_1k w=1u l=48.44u
R_BLEED_1 R_BLEED_seg1 vss vss ppolyf_u_1k w=1u l=48.44u
MM1_0 ndiode vout ntail vss nfet_06v0 w=2u l=2u
MM2_0 ngate vref ntail vss nfet_06v0 w=2u l=2u
MM3_0 ngate ndiode vdd vdd pfet_06v0 w=80u l=0.55u
MM4_0 ndiode ndiode vdd vdd pfet_06v0 w=80u l=0.55u
MM5_0 ntail vb vss vss nfet_06v0 w=100u l=0.7u
MMP_0 vout ngate vdd vdd pfet_06v0 w=20u l=0.55u
MMP_1 vout ngate vdd vdd pfet_06v0 w=20u l=0.55u
MMP_2 vout ngate vdd vdd pfet_06v0 w=20u l=0.55u
MMP_3 vout ngate vdd vdd pfet_06v0 w=20u l=0.55u
MMP_4 vout ngate vdd vdd pfet_06v0 w=20u l=0.55u
MMP_5 vout ngate vdd vdd pfet_06v0 w=20u l=0.55u
MMP_6 vout ngate vdd vdd pfet_06v0 w=20u l=0.55u
MMP_7 vout ngate vdd vdd pfet_06v0 w=20u l=0.55u
MMP_8 vout ngate vdd vdd pfet_06v0 w=20u l=0.55u
MMP_9 vout ngate vdd vdd pfet_06v0 w=20u l=0.55u
MMP_10 vout ngate vdd vdd pfet_06v0 w=20u l=0.55u
MMP_11 vout ngate vdd vdd pfet_06v0 w=20u l=0.55u
MMP_12 vout ngate vdd vdd pfet_06v0 w=20u l=0.55u
MMP_13 vout ngate vdd vdd pfet_06v0 w=20u l=0.55u
MMP_14 vout ngate vdd vdd pfet_06v0 w=20u l=0.55u
MMP_15 vout ngate vdd vdd pfet_06v0 w=20u l=0.55u
MMP_16 vout ngate vdd vdd pfet_06v0 w=20u l=0.55u
MMP_17 vout ngate vdd vdd pfet_06v0 w=20u l=0.55u
MMP_18 vout ngate vdd vdd pfet_06v0 w=20u l=0.55u
MMP_19 vout ngate vdd vdd pfet_06v0 w=20u l=0.55u
MMP_20 vout ngate vdd vdd pfet_06v0 w=20u l=0.55u
MMP_21 vout ngate vdd vdd pfet_06v0 w=20u l=0.55u
MMP_22 vout ngate vdd vdd pfet_06v0 w=20u l=0.55u
MMP_23 vout ngate vdd vdd pfet_06v0 w=20u l=0.55u
MMP_24 vout ngate vdd vdd pfet_06v0 w=20u l=0.55u
MMP_25 vout ngate vdd vdd pfet_06v0 w=20u l=0.55u
MMP_26 vout ngate vdd vdd pfet_06v0 w=20u l=0.55u
MMP_27 vout ngate vdd vdd pfet_06v0 w=20u l=0.55u
MMP_28 vout ngate vdd vdd pfet_06v0 w=20u l=0.55u
MMP_29 vout ngate vdd vdd pfet_06v0 w=20u l=0.55u
MMP_30 vout ngate vdd vdd pfet_06v0 w=20u l=0.55u
MMP_31 vout ngate vdd vdd pfet_06v0 w=20u l=0.55u
MMP_32 vout ngate vdd vdd pfet_06v0 w=20u l=0.55u
MMP_33 vout ngate vdd vdd pfet_06v0 w=20u l=0.55u
MMP_34 vout ngate vdd vdd pfet_06v0 w=20u l=0.55u
MMP_35 vout ngate vdd vdd pfet_06v0 w=20u l=0.55u
MMP_36 vout ngate vdd vdd pfet_06v0 w=20u l=0.55u
MMP_37 vout ngate vdd vdd pfet_06v0 w=20u l=0.55u
MMP_38 vout ngate vdd vdd pfet_06v0 w=20u l=0.55u
MMP_39 vout ngate vdd vdd pfet_06v0 w=20u l=0.55u
MMP_40 vout ngate vdd vdd pfet_06v0 w=20u l=0.55u
MMP_41 vout ngate vdd vdd pfet_06v0 w=20u l=0.55u
MMP_42 vout ngate vdd vdd pfet_06v0 w=20u l=0.55u
MMP_43 vout ngate vdd vdd pfet_06v0 w=20u l=0.55u
MMP_44 vout ngate vdd vdd pfet_06v0 w=20u l=0.55u
MMP_45 vout ngate vdd vdd pfet_06v0 w=20u l=0.55u
MMP_46 vout ngate vdd vdd pfet_06v0 w=20u l=0.55u
MMP_47 vout ngate vdd vdd pfet_06v0 w=20u l=0.55u
MMP_48 vout ngate vdd vdd pfet_06v0 w=20u l=0.55u
MMP_49 vout ngate vdd vdd pfet_06v0 w=20u l=0.55u
MMP_50 vout ngate vdd vdd pfet_06v0 w=20u l=0.55u
MMP_51 vout ngate vdd vdd pfet_06v0 w=20u l=0.55u
MMP_52 vout ngate vdd vdd pfet_06v0 w=20u l=0.55u
MMP_53 vout ngate vdd vdd pfet_06v0 w=20u l=0.55u
MMP_54 vout ngate vdd vdd pfet_06v0 w=20u l=0.55u
MMP_55 vout ngate vdd vdd pfet_06v0 w=20u l=0.55u
MMP_56 vout ngate vdd vdd pfet_06v0 w=20u l=0.55u
MMP_57 vout ngate vdd vdd pfet_06v0 w=20u l=0.55u
MMP_58 vout ngate vdd vdd pfet_06v0 w=20u l=0.55u
MMP_59 vout ngate vdd vdd pfet_06v0 w=20u l=0.55u
MMP_60 vout ngate vdd vdd pfet_06v0 w=20u l=0.55u
MMP_61 vout ngate vdd vdd pfet_06v0 w=20u l=0.55u
MMP_62 vout ngate vdd vdd pfet_06v0 w=20u l=0.55u
MMP_63 vout ngate vdd vdd pfet_06v0 w=20u l=0.55u
MMP_64 vout ngate vdd vdd pfet_06v0 w=20u l=0.55u
MMP_65 vout ngate vdd vdd pfet_06v0 w=20u l=0.55u
MMP_66 vout ngate vdd vdd pfet_06v0 w=20u l=0.55u
MMP_67 vout ngate vdd vdd pfet_06v0 w=20u l=0.55u
MMP_68 vout ngate vdd vdd pfet_06v0 w=20u l=0.55u
MMP_69 vout ngate vdd vdd pfet_06v0 w=20u l=0.55u
MMP_70 vout ngate vdd vdd pfet_06v0 w=20u l=0.55u
MMP_71 vout ngate vdd vdd pfet_06v0 w=20u l=0.55u
MMP_72 vout ngate vdd vdd pfet_06v0 w=20u l=0.55u
MMP_73 vout ngate vdd vdd pfet_06v0 w=20u l=0.55u
MMP_74 vout ngate vdd vdd pfet_06v0 w=20u l=0.55u
MMP_75 vout ngate vdd vdd pfet_06v0 w=20u l=0.55u
MMP_76 vout ngate vdd vdd pfet_06v0 w=20u l=0.55u
MMP_77 vout ngate vdd vdd pfet_06v0 w=20u l=0.55u
MMP_78 vout ngate vdd vdd pfet_06v0 w=20u l=0.55u
MMP_79 vout ngate vdd vdd pfet_06v0 w=20u l=0.55u
MMP_80 vout ngate vdd vdd pfet_06v0 w=20u l=0.55u
MMP_81 vout ngate vdd vdd pfet_06v0 w=20u l=0.55u
MMP_82 vout ngate vdd vdd pfet_06v0 w=20u l=0.55u
MMP_83 vout ngate vdd vdd pfet_06v0 w=20u l=0.55u
MMP_84 vout ngate vdd vdd pfet_06v0 w=20u l=0.55u
MMP_85 vout ngate vdd vdd pfet_06v0 w=20u l=0.55u
MMP_86 vout ngate vdd vdd pfet_06v0 w=20u l=0.55u
MMP_87 vout ngate vdd vdd pfet_06v0 w=20u l=0.55u
MMP_88 vout ngate vdd vdd pfet_06v0 w=20u l=0.55u
MMP_89 vout ngate vdd vdd pfet_06v0 w=20u l=0.55u
MMP_90 vout ngate vdd vdd pfet_06v0 w=20u l=0.55u
MMP_91 vout ngate vdd vdd pfet_06v0 w=20u l=0.55u
MMP_92 vout ngate vdd vdd pfet_06v0 w=20u l=0.55u
MMP_93 vout ngate vdd vdd pfet_06v0 w=20u l=0.55u
MMP_94 vout ngate vdd vdd pfet_06v0 w=20u l=0.55u
MMP_95 vout ngate vdd vdd pfet_06v0 w=20u l=0.55u
MMP_96 vout ngate vdd vdd pfet_06v0 w=20u l=0.55u
MMP_97 vout ngate vdd vdd pfet_06v0 w=20u l=0.55u
MMP_98 vout ngate vdd vdd pfet_06v0 w=20u l=0.55u
MMP_99 vout ngate vdd vdd pfet_06v0 w=20u l=0.55u
MMP_100 vout ngate vdd vdd pfet_06v0 w=20u l=0.55u
MMP_101 vout ngate vdd vdd pfet_06v0 w=20u l=0.55u
MMP_102 vout ngate vdd vdd pfet_06v0 w=20u l=0.55u
MMP_103 vout ngate vdd vdd pfet_06v0 w=20u l=0.55u
MMP_104 vout ngate vdd vdd pfet_06v0 w=20u l=0.55u
MMP_105 vout ngate vdd vdd pfet_06v0 w=20u l=0.55u
MMP_106 vout ngate vdd vdd pfet_06v0 w=20u l=0.55u
MMP_107 vout ngate vdd vdd pfet_06v0 w=20u l=0.55u
MMP_108 vout ngate vdd vdd pfet_06v0 w=20u l=0.55u
MMP_109 vout ngate vdd vdd pfet_06v0 w=20u l=0.55u
MMP_110 vout ngate vdd vdd pfet_06v0 w=20u l=0.55u
MMP_111 vout ngate vdd vdd pfet_06v0 w=20u l=0.55u
MMP_112 vout ngate vdd vdd pfet_06v0 w=20u l=0.55u
MMP_113 vout ngate vdd vdd pfet_06v0 w=20u l=0.55u
MMP_114 vout ngate vdd vdd pfet_06v0 w=20u l=0.55u
MMP_115 vout ngate vdd vdd pfet_06v0 w=20u l=0.55u
MMP_116 vout ngate vdd vdd pfet_06v0 w=20u l=0.55u
MMP_117 vout ngate vdd vdd pfet_06v0 w=20u l=0.55u
MMP_118 vout ngate vdd vdd pfet_06v0 w=20u l=0.55u
MMP_119 vout ngate vdd vdd pfet_06v0 w=20u l=0.55u
MMP_120 vout ngate vdd vdd pfet_06v0 w=20u l=0.55u
MMP_121 vout ngate vdd vdd pfet_06v0 w=20u l=0.55u
MMP_122 vout ngate vdd vdd pfet_06v0 w=20u l=0.55u
MMP_123 vout ngate vdd vdd pfet_06v0 w=20u l=0.55u
MMP_124 vout ngate vdd vdd pfet_06v0 w=20u l=0.55u
MMP_125 vout ngate vdd vdd pfet_06v0 w=20u l=0.55u
MMP_126 vout ngate vdd vdd pfet_06v0 w=20u l=0.55u
MMP_127 vout ngate vdd vdd pfet_06v0 w=20u l=0.55u
MMP_128 vout ngate vdd vdd pfet_06v0 w=20u l=0.55u
MMP_129 vout ngate vdd vdd pfet_06v0 w=20u l=0.55u
MMP_130 vout ngate vdd vdd pfet_06v0 w=20u l=0.55u
MMP_131 vout ngate vdd vdd pfet_06v0 w=20u l=0.55u
MMP_132 vout ngate vdd vdd pfet_06v0 w=20u l=0.55u
MMP_133 vout ngate vdd vdd pfet_06v0 w=20u l=0.55u
MMP_134 vout ngate vdd vdd pfet_06v0 w=20u l=0.55u
MMP_135 vout ngate vdd vdd pfet_06v0 w=20u l=0.55u
MMP_136 vout ngate vdd vdd pfet_06v0 w=20u l=0.55u
MMP_137 vout ngate vdd vdd pfet_06v0 w=20u l=0.55u
MMP_138 vout ngate vdd vdd pfet_06v0 w=20u l=0.55u
MMP_139 vout ngate vdd vdd pfet_06v0 w=20u l=0.55u
MMP_140 vout ngate vdd vdd pfet_06v0 w=20u l=0.55u
MMP_141 vout ngate vdd vdd pfet_06v0 w=20u l=0.55u
MMP_142 vout ngate vdd vdd pfet_06v0 w=20u l=0.55u
MMP_143 vout ngate vdd vdd pfet_06v0 w=20u l=0.55u
MMP_144 vout ngate vdd vdd pfet_06v0 w=20u l=0.55u
MMP_145 vout ngate vdd vdd pfet_06v0 w=20u l=0.55u
MMP_146 vout ngate vdd vdd pfet_06v0 w=20u l=0.55u
MMP_147 vout ngate vdd vdd pfet_06v0 w=20u l=0.55u
MMP_148 vout ngate vdd vdd pfet_06v0 w=20u l=0.55u
MMP_149 vout ngate vdd vdd pfet_06v0 w=20u l=0.55u
MMP_150 vout ngate vdd vdd pfet_06v0 w=20u l=0.55u
MMP_151 vout ngate vdd vdd pfet_06v0 w=20u l=0.55u
MMP_152 vout ngate vdd vdd pfet_06v0 w=20u l=0.55u
MMP_153 vout ngate vdd vdd pfet_06v0 w=20u l=0.55u
MMP_154 vout ngate vdd vdd pfet_06v0 w=20u l=0.55u
MMP_155 vout ngate vdd vdd pfet_06v0 w=20u l=0.55u
MMP_156 vout ngate vdd vdd pfet_06v0 w=20u l=0.55u
MMP_157 vout ngate vdd vdd pfet_06v0 w=20u l=0.55u
MMP_158 vout ngate vdd vdd pfet_06v0 w=20u l=0.55u
MMP_159 vout ngate vdd vdd pfet_06v0 w=20u l=0.55u
MMP_160 vout ngate vdd vdd pfet_06v0 w=20u l=0.55u
MMP_161 vout ngate vdd vdd pfet_06v0 w=20u l=0.55u
MMP_162 vout ngate vdd vdd pfet_06v0 w=20u l=0.55u
MMP_163 vout ngate vdd vdd pfet_06v0 w=20u l=0.55u
MMP_164 vout ngate vdd vdd pfet_06v0 w=20u l=0.55u
MMP_165 vout ngate vdd vdd pfet_06v0 w=20u l=0.55u
MMP_166 vout ngate vdd vdd pfet_06v0 w=20u l=0.55u
MMP_167 vout ngate vdd vdd pfet_06v0 w=20u l=0.55u
MMP_168 vout ngate vdd vdd pfet_06v0 w=20u l=0.55u
MMP_169 vout ngate vdd vdd pfet_06v0 w=20u l=0.55u
MMP_170 vout ngate vdd vdd pfet_06v0 w=20u l=0.55u
MMP_171 vout ngate vdd vdd pfet_06v0 w=20u l=0.55u
MMP_172 vout ngate vdd vdd pfet_06v0 w=20u l=0.55u
MMP_173 vout ngate vdd vdd pfet_06v0 w=20u l=0.55u
MMP_174 vout ngate vdd vdd pfet_06v0 w=20u l=0.55u
MMP_175 vout ngate vdd vdd pfet_06v0 w=20u l=0.55u
MMP_176 vout ngate vdd vdd pfet_06v0 w=20u l=0.55u
MMP_177 vout ngate vdd vdd pfet_06v0 w=20u l=0.55u
MMP_178 vout ngate vdd vdd pfet_06v0 w=20u l=0.55u
MMP_179 vout ngate vdd vdd pfet_06v0 w=20u l=0.55u
MMP_180 vout ngate vdd vdd pfet_06v0 w=20u l=0.55u
MMP_181 vout ngate vdd vdd pfet_06v0 w=20u l=0.55u
MMP_182 vout ngate vdd vdd pfet_06v0 w=20u l=0.55u
MMP_183 vout ngate vdd vdd pfet_06v0 w=20u l=0.55u
MMP_184 vout ngate vdd vdd pfet_06v0 w=20u l=0.55u
MMP_185 vout ngate vdd vdd pfet_06v0 w=20u l=0.55u
MMP_186 vout ngate vdd vdd pfet_06v0 w=20u l=0.55u
MMP_187 vout ngate vdd vdd pfet_06v0 w=20u l=0.55u
MMP_188 vout ngate vdd vdd pfet_06v0 w=20u l=0.55u
MMP_189 vout ngate vdd vdd pfet_06v0 w=20u l=0.55u
MMP_190 vout ngate vdd vdd pfet_06v0 w=20u l=0.55u
MMP_191 vout ngate vdd vdd pfet_06v0 w=20u l=0.55u
MMP_192 vout ngate vdd vdd pfet_06v0 w=20u l=0.55u
MMP_193 vout ngate vdd vdd pfet_06v0 w=20u l=0.55u
MMP_194 vout ngate vdd vdd pfet_06v0 w=20u l=0.55u
MMP_195 vout ngate vdd vdd pfet_06v0 w=20u l=0.55u
MMP_196 vout ngate vdd vdd pfet_06v0 w=20u l=0.55u
MMP_197 vout ngate vdd vdd pfet_06v0 w=20u l=0.55u
MMP_198 vout ngate vdd vdd pfet_06v0 w=20u l=0.55u
MMP_199 vout ngate vdd vdd pfet_06v0 w=20u l=0.55u
MMP_200 vout ngate vdd vdd pfet_06v0 w=20u l=0.55u
MMP_201 vout ngate vdd vdd pfet_06v0 w=20u l=0.55u
MMP_202 vout ngate vdd vdd pfet_06v0 w=20u l=0.55u
MMP_203 vout ngate vdd vdd pfet_06v0 w=20u l=0.55u
MMP_204 vout ngate vdd vdd pfet_06v0 w=20u l=0.55u
MMP_205 vout ngate vdd vdd pfet_06v0 w=20u l=0.55u
MMP_206 vout ngate vdd vdd pfet_06v0 w=20u l=0.55u
MMP_207 vout ngate vdd vdd pfet_06v0 w=20u l=0.55u
MMP_208 vout ngate vdd vdd pfet_06v0 w=20u l=0.55u
MMP_209 vout ngate vdd vdd pfet_06v0 w=20u l=0.55u
MMP_210 vout ngate vdd vdd pfet_06v0 w=20u l=0.55u
MMP_211 vout ngate vdd vdd pfet_06v0 w=20u l=0.55u
MMP_212 vout ngate vdd vdd pfet_06v0 w=20u l=0.55u
MMP_213 vout ngate vdd vdd pfet_06v0 w=20u l=0.55u
MMP_214 vout ngate vdd vdd pfet_06v0 w=20u l=0.55u
MMP_215 vout ngate vdd vdd pfet_06v0 w=20u l=0.55u
MMP_216 vout ngate vdd vdd pfet_06v0 w=20u l=0.55u
MMP_217 vout ngate vdd vdd pfet_06v0 w=20u l=0.55u
MMP_218 vout ngate vdd vdd pfet_06v0 w=20u l=0.55u
MMP_219 vout ngate vdd vdd pfet_06v0 w=20u l=0.55u
MMP_220 vout ngate vdd vdd pfet_06v0 w=20u l=0.55u
MMP_221 vout ngate vdd vdd pfet_06v0 w=20u l=0.55u
MMP_222 vout ngate vdd vdd pfet_06v0 w=20u l=0.55u
MMP_223 vout ngate vdd vdd pfet_06v0 w=20u l=0.55u
MMP_224 vout ngate vdd vdd pfet_06v0 w=20u l=0.55u
MMP_225 vout ngate vdd vdd pfet_06v0 w=20u l=0.55u
MMP_226 vout ngate vdd vdd pfet_06v0 w=20u l=0.55u
MMP_227 vout ngate vdd vdd pfet_06v0 w=20u l=0.55u
MMP_228 vout ngate vdd vdd pfet_06v0 w=20u l=0.55u
MMP_229 vout ngate vdd vdd pfet_06v0 w=20u l=0.55u
MMP_230 vout ngate vdd vdd pfet_06v0 w=20u l=0.55u
MMP_231 vout ngate vdd vdd pfet_06v0 w=20u l=0.55u
MMP_232 vout ngate vdd vdd pfet_06v0 w=20u l=0.55u
MMP_233 vout ngate vdd vdd pfet_06v0 w=20u l=0.55u
MMP_234 vout ngate vdd vdd pfet_06v0 w=20u l=0.55u
MMP_235 vout ngate vdd vdd pfet_06v0 w=20u l=0.55u
MMP_236 vout ngate vdd vdd pfet_06v0 w=20u l=0.55u
MMP_237 vout ngate vdd vdd pfet_06v0 w=20u l=0.55u
MMP_238 vout ngate vdd vdd pfet_06v0 w=20u l=0.55u
MMP_239 vout ngate vdd vdd pfet_06v0 w=20u l=0.55u
MMP_240 vout ngate vdd vdd pfet_06v0 w=20u l=0.55u
MMP_241 vout ngate vdd vdd pfet_06v0 w=20u l=0.55u
MMP_242 vout ngate vdd vdd pfet_06v0 w=20u l=0.55u
MMP_243 vout ngate vdd vdd pfet_06v0 w=20u l=0.55u
MMP_244 vout ngate vdd vdd pfet_06v0 w=20u l=0.55u
MMP_245 vout ngate vdd vdd pfet_06v0 w=20u l=0.55u
MMP_246 vout ngate vdd vdd pfet_06v0 w=20u l=0.55u
MMP_247 vout ngate vdd vdd pfet_06v0 w=20u l=0.55u
MMP_248 vout ngate vdd vdd pfet_06v0 w=20u l=0.55u
MMP_249 vout ngate vdd vdd pfet_06v0 w=20u l=0.55u
MMP_250 vout ngate vdd vdd pfet_06v0 w=20u l=0.55u
MMP_251 vout ngate vdd vdd pfet_06v0 w=20u l=0.55u
MMP_252 vout ngate vdd vdd pfet_06v0 w=20u l=0.55u
MMP_253 vout ngate vdd vdd pfet_06v0 w=20u l=0.55u
MMP_254 vout ngate vdd vdd pfet_06v0 w=20u l=0.55u
MMP_255 vout ngate vdd vdd pfet_06v0 w=20u l=0.55u
MMP_256 vout ngate vdd vdd pfet_06v0 w=20u l=0.55u
MMP_257 vout ngate vdd vdd pfet_06v0 w=20u l=0.55u
MMP_258 vout ngate vdd vdd pfet_06v0 w=20u l=0.55u
MMP_259 vout ngate vdd vdd pfet_06v0 w=20u l=0.55u
MMP_260 vout ngate vdd vdd pfet_06v0 w=20u l=0.55u
MMP_261 vout ngate vdd vdd pfet_06v0 w=20u l=0.55u
MMP_262 vout ngate vdd vdd pfet_06v0 w=20u l=0.55u
MMP_263 vout ngate vdd vdd pfet_06v0 w=20u l=0.55u
MMP_264 vout ngate vdd vdd pfet_06v0 w=20u l=0.55u
MMP_265 vout ngate vdd vdd pfet_06v0 w=20u l=0.55u
MMP_266 vout ngate vdd vdd pfet_06v0 w=20u l=0.55u
MMP_267 vout ngate vdd vdd pfet_06v0 w=20u l=0.55u
MMP_268 vout ngate vdd vdd pfet_06v0 w=20u l=0.55u
MMP_269 vout ngate vdd vdd pfet_06v0 w=20u l=0.55u
MMP_270 vout ngate vdd vdd pfet_06v0 w=20u l=0.55u
MMP_271 vout ngate vdd vdd pfet_06v0 w=20u l=0.55u
MMP_272 vout ngate vdd vdd pfet_06v0 w=20u l=0.55u
MMP_273 vout ngate vdd vdd pfet_06v0 w=20u l=0.55u
MMP_274 vout ngate vdd vdd pfet_06v0 w=20u l=0.55u
MMP_275 vout ngate vdd vdd pfet_06v0 w=20u l=0.55u
MMP_276 vout ngate vdd vdd pfet_06v0 w=20u l=0.55u
MMP_277 vout ngate vdd vdd pfet_06v0 w=20u l=0.55u
MMP_278 vout ngate vdd vdd pfet_06v0 w=20u l=0.55u
MMP_279 vout ngate vdd vdd pfet_06v0 w=20u l=0.55u
MMP_280 vout ngate vdd vdd pfet_06v0 w=20u l=0.55u
MMP_281 vout ngate vdd vdd pfet_06v0 w=20u l=0.55u
MMP_282 vout ngate vdd vdd pfet_06v0 w=20u l=0.55u
MMP_283 vout ngate vdd vdd pfet_06v0 w=20u l=0.55u
MMP_284 vout ngate vdd vdd pfet_06v0 w=20u l=0.55u
MMP_285 vout ngate vdd vdd pfet_06v0 w=20u l=0.55u
MMP_286 vout ngate vdd vdd pfet_06v0 w=20u l=0.55u
MMP_287 vout ngate vdd vdd pfet_06v0 w=20u l=0.55u
MMP_288 vout ngate vdd vdd pfet_06v0 w=20u l=0.55u
MMP_289 vout ngate vdd vdd pfet_06v0 w=20u l=0.55u
MMP_290 vout ngate vdd vdd pfet_06v0 w=20u l=0.55u
MMP_291 vout ngate vdd vdd pfet_06v0 w=20u l=0.55u
MMP_292 vout ngate vdd vdd pfet_06v0 w=20u l=0.55u
MMP_293 vout ngate vdd vdd pfet_06v0 w=20u l=0.55u
MMP_294 vout ngate vdd vdd pfet_06v0 w=20u l=0.55u
MMP_295 vout ngate vdd vdd pfet_06v0 w=20u l=0.55u
MMP_296 vout ngate vdd vdd pfet_06v0 w=20u l=0.55u
MMP_297 vout ngate vdd vdd pfet_06v0 w=20u l=0.55u
MMP_298 vout ngate vdd vdd pfet_06v0 w=20u l=0.55u
MMP_299 vout ngate vdd vdd pfet_06v0 w=20u l=0.55u
MMP_300 vout ngate vdd vdd pfet_06v0 w=20u l=0.55u
MMP_301 vout ngate vdd vdd pfet_06v0 w=20u l=0.55u
MMP_302 vout ngate vdd vdd pfet_06v0 w=20u l=0.55u
MMP_303 vout ngate vdd vdd pfet_06v0 w=20u l=0.55u
MMP_304 vout ngate vdd vdd pfet_06v0 w=20u l=0.55u
MMP_305 vout ngate vdd vdd pfet_06v0 w=20u l=0.55u
MMP_306 vout ngate vdd vdd pfet_06v0 w=20u l=0.55u
MMP_307 vout ngate vdd vdd pfet_06v0 w=20u l=0.55u
MMP_308 vout ngate vdd vdd pfet_06v0 w=20u l=0.55u
MMP_309 vout ngate vdd vdd pfet_06v0 w=20u l=0.55u
MMP_310 vout ngate vdd vdd pfet_06v0 w=20u l=0.55u
MMP_311 vout ngate vdd vdd pfet_06v0 w=20u l=0.55u
MMP_312 vout ngate vdd vdd pfet_06v0 w=20u l=0.55u
MMP_313 vout ngate vdd vdd pfet_06v0 w=20u l=0.55u
MMP_314 vout ngate vdd vdd pfet_06v0 w=20u l=0.55u
MMP_315 vout ngate vdd vdd pfet_06v0 w=20u l=0.55u
MMP_316 vout ngate vdd vdd pfet_06v0 w=20u l=0.55u
MMP_317 vout ngate vdd vdd pfet_06v0 w=20u l=0.55u
MMP_318 vout ngate vdd vdd pfet_06v0 w=20u l=0.55u
MMP_319 vout ngate vdd vdd pfet_06v0 w=20u l=0.55u
MMP_320 vout ngate vdd vdd pfet_06v0 w=20u l=0.55u
MMP_321 vout ngate vdd vdd pfet_06v0 w=20u l=0.55u
MMP_322 vout ngate vdd vdd pfet_06v0 w=20u l=0.55u
MMP_323 vout ngate vdd vdd pfet_06v0 w=20u l=0.55u
MMP_324 vout ngate vdd vdd pfet_06v0 w=20u l=0.55u
MMP_325 vout ngate vdd vdd pfet_06v0 w=20u l=0.55u
MMP_326 vout ngate vdd vdd pfet_06v0 w=20u l=0.55u
MMP_327 vout ngate vdd vdd pfet_06v0 w=20u l=0.55u
MMP_328 vout ngate vdd vdd pfet_06v0 w=20u l=0.55u
MMP_329 vout ngate vdd vdd pfet_06v0 w=20u l=0.55u
MMP_330 vout ngate vdd vdd pfet_06v0 w=20u l=0.55u
MMP_331 vout ngate vdd vdd pfet_06v0 w=20u l=0.55u
MMP_332 vout ngate vdd vdd pfet_06v0 w=20u l=0.55u
MMP_333 vout ngate vdd vdd pfet_06v0 w=20u l=0.55u
MMP_334 vout ngate vdd vdd pfet_06v0 w=20u l=0.55u
MMP_335 vout ngate vdd vdd pfet_06v0 w=20u l=0.55u
MMP_336 vout ngate vdd vdd pfet_06v0 w=20u l=0.55u
MMP_337 vout ngate vdd vdd pfet_06v0 w=20u l=0.55u
MMP_338 vout ngate vdd vdd pfet_06v0 w=20u l=0.55u
MMP_339 vout ngate vdd vdd pfet_06v0 w=20u l=0.55u
MMP_340 vout ngate vdd vdd pfet_06v0 w=20u l=0.55u
MMP_341 vout ngate vdd vdd pfet_06v0 w=20u l=0.55u
MMP_342 vout ngate vdd vdd pfet_06v0 w=20u l=0.55u
MMP_343 vout ngate vdd vdd pfet_06v0 w=20u l=0.55u
MMP_344 vout ngate vdd vdd pfet_06v0 w=20u l=0.55u
MMP_345 vout ngate vdd vdd pfet_06v0 w=20u l=0.55u
MMP_346 vout ngate vdd vdd pfet_06v0 w=20u l=0.55u
MMP_347 vout ngate vdd vdd pfet_06v0 w=20u l=0.55u
MMP_348 vout ngate vdd vdd pfet_06v0 w=20u l=0.55u
MMP_349 vout ngate vdd vdd pfet_06v0 w=20u l=0.55u
MMP_350 vout ngate vdd vdd pfet_06v0 w=20u l=0.55u
MMP_351 vout ngate vdd vdd pfet_06v0 w=20u l=0.55u
MMP_352 vout ngate vdd vdd pfet_06v0 w=20u l=0.55u
MMP_353 vout ngate vdd vdd pfet_06v0 w=20u l=0.55u
MMP_354 vout ngate vdd vdd pfet_06v0 w=20u l=0.55u
MMP_355 vout ngate vdd vdd pfet_06v0 w=20u l=0.55u
MMP_356 vout ngate vdd vdd pfet_06v0 w=20u l=0.55u
MMP_357 vout ngate vdd vdd pfet_06v0 w=20u l=0.55u
MMP_358 vout ngate vdd vdd pfet_06v0 w=20u l=0.55u
MMP_359 vout ngate vdd vdd pfet_06v0 w=20u l=0.55u
.ends ldo_003_analoggym_simple
