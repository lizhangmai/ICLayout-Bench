* Independently authored Bench measurements; SPDX-License-Identifier: MIT
.include support/models.spice
.include dut.spice
.include parameters.spice
.temp 27
.options reltol=1e-6 abstol=1e-13 vntol=1e-9
VDD vdd 0 dc {supply_v} ac 1 pulse({supply_v} {supply_v+line_step_v} 20u 100n 100n 40u 200u)
VSS vss 0 0
VB vb 0 1.2
VREF vref 0 1.8
ILOAD vout 0 dc {load_a} pulse({load_a} {load_a+load_step_a} 20u 100n 100n 40u 200u)
RESR vout cout .1
COUT cout 0 50p
XDUT vdd vout vss vb vref ldo_003_analoggym_simple
.save v(vdd) v(vss) v(vout) v(cout) v(vb) v(vref) i(vdd) i(vss) i(vb) i(vref) @iload[current]
.control
set numdgt=15
set measdgt=15
op
let output_v=v(vout)
let regulation_error_v=abs(v(vout)-1.8)
let power_w=-v(vdd)*i(vdd)-v(vb)*i(vb)-v(vref)*i(vref)
let kcl_a=abs(i(vdd)+i(vss)+i(vb)+i(vref)+@iload[current])
print output_v regulation_error_v power_w kcl_a
write op.raw all
ac dec 100 1 100Meg
let rejection=-db(v(vout))
meas ac psrr_db find rejection at=1k
write ac.raw all
tran 2n 100u 0 2n
let err=abs(v(vout)-1.8)
meas tran quiet_v avg v(vout) from=10u to=20u
meas tran quiet_ripple_v pp v(vout) from=10u to=20u
meas tran high_v avg v(vout) from=50u to=60u
meas tran recovery_v avg v(vout) from=90u to=100u
meas tran recovery_ripple_v pp v(vout) from=90u to=100u
meas tran excursion_v pp v(vout) from=20u to=100u
meas tran late_error_v avg err from=90u to=100u
write transient.raw all
quit
.endc
.end
