* Independently authored Bench measurements; SPDX-License-Identifier: MIT
.include support/models.spice
.include dut.spice
.include parameters.spice
.temp 27
.options reltol=1e-6 abstol=1e-13 vntol=1e-9
VSS vss 0 0
VDD vdd 0 PWL(0 0 10u 2 100u 2)
VB vb 0 PWL(0 0 10u 1.2 100u 1.2)
VREF vref 0 PWL(0 0 10u 1.8 100u 1.8)
RLOAD vout 0 1800
RESR vout cout .1
COUT cout 0 50p
XDUT vdd vout vss vb vref ldo_003_analoggym_simple
.save v(vdd) v(vss) v(vout) v(cout) v(vb) v(vref) i(vdd) i(vss) i(vb) i(vref)
.control
set numdgt=15
set measdgt=15
tran 2n 100u 0 2n
let err=abs(v(vout)-1.8)
meas tran startup_error_v avg err from=90u to=100u
meas tran startup_ripple_v pp v(vout) from=90u to=100u
write transient.raw all
quit
.endc
.end
