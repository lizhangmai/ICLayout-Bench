* Derived from analog-db gs_001_cascode_cs, GF180 binding at
* 263d0322f8900dc331536fbbe6c0e804514fc454. Copyright 2026 Danial Noori Zadeh.
* See collection LICENSE and NOTICE. Layout-Bench changes: fixed dimensions and explicit body rails.
.subckt gs_001_cascode_cs vdd vout vin ibias vss
XMNB1 nbias1 nbias1 vss vss nfet_03v3 w=6u l=0.3u m=1
XMNB2 nbias2 nbias2 nbias1 vss nfet_03v3 w=6u l=0.3u m=1
XMNCA vout nbias2 nint vss nfet_03v3 w=4u l=0.3u m=1
XMNIN nint vin vss vss nfet_03v3 w=4u l=0.3u m=1
XMPB1 pbias1 pbias1 vdd vdd pfet_03v3 w=16u l=0.5u m=1
XMPB2 ibias ibias pbias1 vdd pfet_03v3 w=16u l=0.5u m=1
XMPCA vout ibias pint vdd pfet_03v3 w=10u l=0.5u m=1
XMPLD pint pbias1 vdd vdd pfet_03v3 w=10u l=0.5u m=1
XMPNR nbias2 ibias vdd vdd pfet_03v3 w=0.5u l=0.5u m=1
.ends gs_001_cascode_cs
