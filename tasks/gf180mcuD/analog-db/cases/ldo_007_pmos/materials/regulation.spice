* Regulator nominal and finite-window perturbation observations.
.include support/models.spice
.include dut.spice
.include parameters.spice
.temp 27
.save v(vdd) v(vss) v(vout) v(cout) v(vref) i(vdd) i(vss) i(vref) v(ebias) @iload[current]
VSS vss 0 0
.options reltol=1e-6 abstol=1e-13 vntol=1e-9
VDD vdd 0 dc {supply_v} ac 1 pulse({supply_v} {supply_v+line_step_v} 100u 1u 1u 100u 500u)
IBIAS vdd ebias 60u
VREF vref 0 1.05
ILOAD vout 0 dc {load_a} pulse({load_a} {load_a+load_step_a} 100u 1u 1u 100u 500u)
RESR vout cout .1
COUT cout 0 1n
XDUT vdd vout vss ebias vref ldo_007_pmos
.control
set numdgt=15
op
let kcl_a=abs(i(vdd)+i(vss)+i(vref)+@iload[current])
print kcl_a
write op.raw all
dc VDD 1.8 1.9000000000000001 .01
let line_reg_v_per_v=abs((v(vout)[length(v(vout))-1]-v(vout)[0])/.1)
print line_reg_v_per_v
write line.raw all
dc ILOAD .001 .002 .0001
let load_reg_ohm=abs((v(vout)[length(v(vout))-1]-v(vout)[0])/.001)
print load_reg_ohm
write load.raw all
quit
.endc
.end
